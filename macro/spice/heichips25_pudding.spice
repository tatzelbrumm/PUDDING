* NGSPICE file created from heichips25_pudding.ext - technology: ihp-sg13g2

* Black-box entry subcircuit for sg13g2_decap_8 abstract view
.subckt sg13g2_decap_8 VDD VSS
.ends

* Black-box entry subcircuit for sg13g2_fill_1 abstract view
.subckt sg13g2_fill_1 VDD VSS
.ends

* Black-box entry subcircuit for sg13g2_fill_2 abstract view
.subckt sg13g2_fill_2 VDD VSS
.ends

* Black-box entry subcircuit for sg13g2_decap_4 abstract view
.subckt sg13g2_decap_4 VDD VSS
.ends

* Black-box entry subcircuit for sg13g2_dfrbpq_1 abstract view
.subckt sg13g2_dfrbpq_1 RESET_B VSS VDD D Q CLK
.ends

* Black-box entry subcircuit for sg13g2_buf_1 abstract view
.subckt sg13g2_buf_1 A X VDD VSS
.ends

* Black-box entry subcircuit for sg13g2_o21ai_1 abstract view
.subckt sg13g2_o21ai_1 B1 VDD Y VSS A1 A2
.ends

* Black-box entry subcircuit for sg13g2_buf_8 abstract view
.subckt sg13g2_buf_8 A X VDD VSS
.ends

* Black-box entry subcircuit for sg13g2_inv_1 abstract view
.subckt sg13g2_inv_1 VDD Y A VSS
.ends

* Black-box entry subcircuit for sg13g2_a21o_1 abstract view
.subckt sg13g2_a21o_1 A2 A1 B1 X VDD VSS
.ends

* Black-box entry subcircuit for sg13g2_a22oi_1 abstract view
.subckt sg13g2_a22oi_1 Y B1 B2 A2 A1 VDD VSS
.ends

* Black-box entry subcircuit for sg13g2_antennanp abstract view
.subckt sg13g2_antennanp VDD VSS A
.ends

* Black-box entry subcircuit for sg13g2_a21oi_1 abstract view
.subckt sg13g2_a21oi_1 VSS VDD A1 A2 Y B1
.ends

* Black-box entry subcircuit for sg13g2_buf_16 abstract view
.subckt sg13g2_buf_16 X A VDD VSS
.ends

* Black-box entry subcircuit for sg13g2_or2_1 abstract view
.subckt sg13g2_or2_1 VSS VDD X B A
.ends

* Black-box entry subcircuit for sg13g2_nor2b_1 abstract view
.subckt sg13g2_nor2b_1 A B_N Y VDD VSS
.ends

* Black-box entry subcircuit for sg13g2_tiehi abstract view
.subckt sg13g2_tiehi VDD VSS L_HI
.ends

* Black-box entry subcircuit for sg13g2_nand2_1 abstract view
.subckt sg13g2_nand2_1 Y A B VDD VSS
.ends

* Black-box entry subcircuit for sg13g2_nor2_1 abstract view
.subckt sg13g2_nor2_1 A B Y VDD VSS
.ends

* Black-box entry subcircuit for analog_wires abstract view
.subckt analog_wires VcascP[0] VcascP[1] Iout[0] VDDA[0] VDDA[1] VbiasP[1] VbiasP[0]
+ VcascP[2] VcascP[3] Iout[1] VDDA[2] VDDA[3] VbiasP[3] VbiasP[2] i_in i_out
.ends

* Black-box entry subcircuit for dac32module abstract view
.subckt dac32module EN[1] ENB[1] EN[2] ENB[2] ON[16] ONB[16] ON[17] ONB[17] ON[18]
+ ONB[18] ON[19] ONB[19] ON[20] ONB[20] ON[21] ONB[21] ON[22] ONB[22] ON[23] ONB[23]
+ ON[24] ONB[24] ON[25] ONB[25] ON[26] ONB[26] ON[27] ONB[27] ON[28] ONB[28] ON[29]
+ ONB[29] ON[30] ONB[30] ON[31] ONB[31] EN[3] ENB[3] ON[0] ONB[0] ON[1] ONB[1] ON[2]
+ ONB[2] ON[3] ONB[3] ON[4] ONB[4] ON[5] ONB[5] ON[6] EN[0] ENB[0] ONB[6] ON[7] ONB[7]
+ ON[8] ONB[8] ON[9] ONB[9] ON[10] ONB[10] ON[11] ONB[11] ON[12] ONB[12] ON[13] ONB[13]
+ ON[14] ONB[14] ON[15] ONB[15] Iout VbiasP[0] VbiasP[1] VcascP[1] VcascP[0] VDD VSS
.ends

.subckt heichips25_pudding VGND VPWR clk ena i_in i_out rst_n ui_in[0] ui_in[1] ui_in[2]
+ ui_in[3] ui_in[4] ui_in[5] ui_in[6] ui_in[7] uio_in[0] uio_in[1] uio_in[2] uio_in[3]
+ uio_in[4] uio_in[5] uio_in[6] uio_in[7] uio_oe[0] uio_oe[1] uio_oe[2] uio_oe[3]
+ uio_oe[4] uio_oe[5] uio_oe[6] uio_oe[7] uio_out[0] uio_out[1] uio_out[2] uio_out[3]
+ uio_out[4] uio_out[5] uio_out[6] uio_out[7] uo_out[0] uo_out[1] uo_out[2] uo_out[3]
+ uo_out[4] uo_out[5] uo_out[6] uo_out[7]
XFILLER_39_266 VPWR VGND sg13g2_decap_8
XFILLER_22_111 VPWR VGND sg13g2_decap_8
XFILLER_22_188 VPWR VGND sg13g2_decap_8
XFILLER_23_601 VPWR VGND sg13g2_decap_8
XFILLER_35_461 VPWR VGND sg13g2_decap_8
XFILLER_7_7 VPWR VGND sg13g2_decap_8
XFILLER_13_111 VPWR VGND sg13g2_decap_8
XFILLER_14_601 VPWR VGND sg13g2_decap_8
XFILLER_14_612 VPWR VGND sg13g2_fill_1
XFILLER_14_656 VPWR VGND sg13g2_fill_2
XFILLER_26_483 VPWR VGND sg13g2_decap_8
XFILLER_26_63 VPWR VGND sg13g2_decap_8
XFILLER_41_420 VPWR VGND sg13g2_decap_8
XFILLER_45_203 VPWR VGND sg13g2_decap_8
XFILLER_13_188 VPWR VGND sg13g2_decap_8
XFILLER_41_497 VPWR VGND sg13g2_decap_8
XFILLER_42_84 VPWR VGND sg13g2_decap_8
XFILLER_9_137 VPWR VGND sg13g2_decap_8
XFILLER_1_560 VPWR VGND sg13g2_decap_8
XFILLER_5_354 VPWR VGND sg13g2_decap_8
XFILLER_36_225 VPWR VGND sg13g2_decap_8
XFILLER_3_67 VPWR VGND sg13g2_decap_8
XFILLER_49_564 VPWR VGND sg13g2_decap_8
XFILLER_17_472 VPWR VGND sg13g2_decap_8
XFILLER_20_626 VPWR VGND sg13g2_decap_4
XFILLER_32_431 VPWR VGND sg13g2_decap_8
XFILLER_44_280 VPWR VGND sg13g2_decap_8
X_0985_ net110 VGND VPWR _0145_ state\[17\] clknet_5_31__leaf_clk sg13g2_dfrbpq_1
XFILLER_9_693 VPWR VGND sg13g2_fill_1
Xfanout105 net106 net105 VPWR VGND sg13g2_buf_1
Xfanout116 net121 net116 VPWR VGND sg13g2_buf_1
XFILLER_27_258 VPWR VGND sg13g2_decap_8
XFILLER_28_737 VPWR VGND sg13g2_fill_1
XFILLER_42_217 VPWR VGND sg13g2_decap_8
XFILLER_10_158 VPWR VGND sg13g2_decap_8
XFILLER_11_626 VPWR VGND sg13g2_fill_1
XFILLER_12_32 VPWR VGND sg13g2_decap_8
XFILLER_23_475 VPWR VGND sg13g2_decap_8
XFILLER_2_368 VPWR VGND sg13g2_decap_8
XFILLER_5_4 VPWR VGND sg13g2_decap_8
XFILLER_37_40 VPWR VGND sg13g2_decap_8
XFILLER_46_567 VPWR VGND sg13g2_decap_8
XFILLER_14_475 VPWR VGND sg13g2_decap_8
XFILLER_18_269 VPWR VGND sg13g2_decap_8
XFILLER_26_280 VPWR VGND sg13g2_decap_8
XFILLER_41_294 VPWR VGND sg13g2_decap_8
X_0770_ _0409_ VPWR _0178_ VGND net98 _0009_ sg13g2_o21ai_1
XFILLER_5_151 VPWR VGND sg13g2_decap_8
XFILLER_37_545 VPWR VGND sg13g2_decap_8
XFILLER_49_361 VPWR VGND sg13g2_decap_8
XFILLER_20_412 VPWR VGND sg13g2_decap_8
X_0968_ net101 VGND VPWR _0128_ state\[0\] clknet_5_22__leaf_clk sg13g2_dfrbpq_1
Xclkbuf_4_12_0_clk clknet_0_clk clknet_4_12_0_clk VPWR VGND sg13g2_buf_8
XFILLER_0_817 VPWR VGND sg13g2_decap_4
X_0899_ VPWR _0249_ daisychain\[56\] VGND sg13g2_inv_1
XFILLER_28_523 VPWR VGND sg13g2_decap_8
XFILLER_15_217 VPWR VGND sg13g2_decap_8
XFILLER_23_272 VPWR VGND sg13g2_decap_8
XFILLER_24_762 VPWR VGND sg13g2_fill_1
XFILLER_43_504 VPWR VGND sg13g2_decap_8
XFILLER_11_445 VPWR VGND sg13g2_decap_8
XFILLER_23_97 VPWR VGND sg13g2_decap_8
XFILLER_7_427 VPWR VGND sg13g2_decap_8
XFILLER_2_165 VPWR VGND sg13g2_decap_8
XFILLER_3_655 VPWR VGND sg13g2_decap_8
XFILLER_0_35 VPWR VGND sg13g2_decap_8
XFILLER_19_512 VPWR VGND sg13g2_decap_8
XFILLER_34_504 VPWR VGND sg13g2_decap_8
XFILLER_46_364 VPWR VGND sg13g2_decap_8
XFILLER_14_272 VPWR VGND sg13g2_decap_8
XFILLER_30_732 VPWR VGND sg13g2_decap_8
XFILLER_30_798 VPWR VGND sg13g2_decap_8
XFILLER_42_581 VPWR VGND sg13g2_decap_8
X_0822_ VPWR _0041_ state\[18\] VGND sg13g2_inv_1
XFILLER_9_88 VPWR VGND sg13g2_decap_8
XFILLER_9_11 VPWR VGND sg13g2_decap_8
X_0753_ _0358_ VPWR _0161_ VGND net94 _0011_ sg13g2_o21ai_1
X_0684_ _0248_ net70 _0423_ _0424_ VPWR VGND sg13g2_a21o_1
XFILLER_37_320 VPWR VGND sg13g2_decap_8
XFILLER_25_515 VPWR VGND sg13g2_decap_8
XFILLER_40_518 VPWR VGND sg13g2_decap_8
XFILLER_20_286 VPWR VGND sg13g2_decap_8
XFILLER_0_658 VPWR VGND sg13g2_decap_8
XFILLER_16_504 VPWR VGND sg13g2_decap_8
XFILLER_18_20 VPWR VGND sg13g2_fill_2
XFILLER_18_31 VPWR VGND sg13g2_decap_8
XFILLER_28_320 VPWR VGND sg13g2_decap_8
XFILLER_28_397 VPWR VGND sg13g2_decap_8
XFILLER_29_821 VPWR VGND sg13g2_fill_2
XFILLER_43_301 VPWR VGND sg13g2_decap_8
XFILLER_11_242 VPWR VGND sg13g2_decap_8
XFILLER_12_743 VPWR VGND sg13g2_fill_1
XFILLER_31_529 VPWR VGND sg13g2_decap_8
XFILLER_34_63 VPWR VGND sg13g2_decap_8
XFILLER_43_378 VPWR VGND sg13g2_decap_8
XFILLER_3_452 VPWR VGND sg13g2_decap_8
XFILLER_7_224 VPWR VGND sg13g2_decap_8
XFILLER_15_581 VPWR VGND sg13g2_decap_8
XFILLER_19_386 VPWR VGND sg13g2_decap_8
XFILLER_34_301 VPWR VGND sg13g2_decap_8
XFILLER_34_378 VPWR VGND sg13g2_decap_8
XFILLER_46_161 VPWR VGND sg13g2_decap_8
XFILLER_47_651 VPWR VGND sg13g2_decap_8
X_1021_ net119 VGND VPWR _0181_ state\[53\] clknet_5_15__leaf_clk sg13g2_dfrbpq_1
X_0805_ VPWR _0202_ daisychain\[9\] VGND sg13g2_inv_1
X_0736_ _0307_ VPWR _0144_ VGND net90 _0039_ sg13g2_o21ai_1
X_0667_ net97 VPWR _0411_ VGND net75 state\[51\] sg13g2_o21ai_1
X_0598_ _0097_ _0358_ _0359_ net49 _0226_ VPWR VGND sg13g2_a22oi_1
XFILLER_25_312 VPWR VGND sg13g2_decap_8
XFILLER_26_802 VPWR VGND sg13g2_fill_2
XFILLER_29_117 VPWR VGND sg13g2_decap_8
XFILLER_21_562 VPWR VGND sg13g2_decap_8
XFILLER_25_389 VPWR VGND sg13g2_decap_8
XFILLER_37_194 VPWR VGND sg13g2_decap_8
XFILLER_40_315 VPWR VGND sg13g2_decap_8
XFILLER_20_76 VPWR VGND sg13g2_decap_8
XFILLER_4_249 VPWR VGND sg13g2_decap_8
XFILLER_0_455 VPWR VGND sg13g2_decap_8
XFILLER_29_96 VPWR VGND sg13g2_decap_8
XFILLER_48_448 VPWR VGND sg13g2_decap_8
XFILLER_16_301 VPWR VGND sg13g2_decap_8
XFILLER_16_378 VPWR VGND sg13g2_decap_8
XFILLER_28_194 VPWR VGND sg13g2_decap_8
XFILLER_29_673 VPWR VGND sg13g2_decap_4
XFILLER_31_326 VPWR VGND sg13g2_decap_8
XFILLER_43_175 VPWR VGND sg13g2_decap_8
XFILLER_44_665 VPWR VGND sg13g2_decap_4
XFILLER_45_84 VPWR VGND sg13g2_decap_8
XFILLER_8_588 VPWR VGND sg13g2_decap_4
XFILLER_8_511 VPWR VGND sg13g2_decap_8
XANTENNA_5 VPWR VGND digitalen.g\[0\].u.OUTP sg13g2_antennanp
X_0521_ VGND VPWR net25 daisychain\[13\] _0302_ net41 sg13g2_a21oi_1
X_0452_ VPWR _0019_ state\[59\] VGND sg13g2_inv_1
XFILLER_6_67 VPWR VGND sg13g2_decap_8
XFILLER_19_183 VPWR VGND sg13g2_decap_8
XFILLER_39_448 VPWR VGND sg13g2_decap_8
XFILLER_34_175 VPWR VGND sg13g2_decap_8
X_1004_ net114 VGND VPWR _0164_ state\[36\] clknet_5_1__leaf_clk sg13g2_dfrbpq_1
X_0719_ _0127_ _0449_ _0450_ net33 _0256_ VPWR VGND sg13g2_a22oi_1
XFILLER_26_665 VPWR VGND sg13g2_decap_4
XFILLER_26_676 VPWR VGND sg13g2_fill_1
XFILLER_41_602 VPWR VGND sg13g2_decap_8
XFILLER_15_98 VPWR VGND sg13g2_decap_8
XFILLER_21_381 VPWR VGND sg13g2_decap_8
XFILLER_25_186 VPWR VGND sg13g2_decap_8
XFILLER_31_53 VPWR VGND sg13g2_decap_8
XFILLER_40_112 VPWR VGND sg13g2_decap_8
XFILLER_40_189 VPWR VGND sg13g2_decap_8
XFILLER_9_319 VPWR VGND sg13g2_decap_8
Xoutput7 net7 uio_out[0] VPWR VGND sg13g2_buf_1
Xoutput20 net20 uo_out[5] VPWR VGND sg13g2_buf_1
XFILLER_5_536 VPWR VGND sg13g2_decap_8
XFILLER_0_252 VPWR VGND sg13g2_decap_8
XFILLER_29_481 VPWR VGND sg13g2_decap_8
XFILLER_48_245 VPWR VGND sg13g2_decap_8
XFILLER_49_746 VPWR VGND sg13g2_decap_8
XFILLER_16_175 VPWR VGND sg13g2_decap_8
XFILLER_17_676 VPWR VGND sg13g2_decap_8
XFILLER_20_819 VPWR VGND sg13g2_decap_4
XFILLER_31_123 VPWR VGND sg13g2_decap_8
XFILLER_44_462 VPWR VGND sg13g2_decap_8
Xclkbuf_5_17__f_clk clknet_5_17__leaf_clk clknet_4_8_0_clk VPWR VGND sg13g2_buf_16
XFILLER_8_385 VPWR VGND sg13g2_decap_8
X_0504_ _0203_ net64 _0288_ _0289_ VPWR VGND sg13g2_a21o_1
XFILLER_35_440 VPWR VGND sg13g2_decap_8
XFILLER_39_245 VPWR VGND sg13g2_decap_8
XFILLER_22_167 VPWR VGND sg13g2_decap_8
XFILLER_23_679 VPWR VGND sg13g2_fill_1
XFILLER_13_167 VPWR VGND sg13g2_decap_8
XFILLER_26_42 VPWR VGND sg13g2_decap_8
XFILLER_26_462 VPWR VGND sg13g2_decap_8
XFILLER_41_476 VPWR VGND sg13g2_decap_8
XFILLER_45_259 VPWR VGND sg13g2_decap_8
XFILLER_9_116 VPWR VGND sg13g2_decap_8
XFILLER_42_63 VPWR VGND sg13g2_decap_8
XFILLER_6_812 VPWR VGND sg13g2_decap_8
XFILLER_5_333 VPWR VGND sg13g2_decap_8
XFILLER_3_46 VPWR VGND sg13g2_decap_8
XFILLER_17_451 VPWR VGND sg13g2_decap_8
XFILLER_36_204 VPWR VGND sg13g2_decap_8
XFILLER_49_543 VPWR VGND sg13g2_decap_8
XFILLER_20_605 VPWR VGND sg13g2_fill_1
XFILLER_32_410 VPWR VGND sg13g2_decap_8
XFILLER_32_487 VPWR VGND sg13g2_decap_8
X_0984_ net110 VGND VPWR _0144_ state\[16\] clknet_5_31__leaf_clk sg13g2_dfrbpq_1
XFILLER_8_182 VPWR VGND sg13g2_decap_8
Xfanout106 net112 net106 VPWR VGND sg13g2_buf_1
Xfanout117 net120 net117 VPWR VGND sg13g2_buf_1
XFILLER_23_454 VPWR VGND sg13g2_decap_8
XFILLER_27_237 VPWR VGND sg13g2_decap_8
XFILLER_10_137 VPWR VGND sg13g2_decap_8
XFILLER_12_11 VPWR VGND sg13g2_decap_8
XFILLER_12_88 VPWR VGND sg13g2_decap_8
XFILLER_7_609 VPWR VGND sg13g2_decap_8
XFILLER_2_347 VPWR VGND sg13g2_decap_8
XFILLER_18_248 VPWR VGND sg13g2_decap_8
XFILLER_37_96 VPWR VGND sg13g2_decap_8
XFILLER_46_546 VPWR VGND sg13g2_decap_8
XFILLER_14_454 VPWR VGND sg13g2_decap_8
XFILLER_41_273 VPWR VGND sg13g2_decap_8
XFILLER_6_620 VPWR VGND sg13g2_fill_2
XFILLER_5_130 VPWR VGND sg13g2_decap_8
XFILLER_37_524 VPWR VGND sg13g2_decap_8
XFILLER_49_340 VPWR VGND sg13g2_decap_8
XFILLER_18_782 VPWR VGND sg13g2_decap_4
XFILLER_33_741 VPWR VGND sg13g2_fill_2
XFILLER_20_468 VPWR VGND sg13g2_decap_8
XFILLER_32_284 VPWR VGND sg13g2_decap_8
X_0967_ net123 VGND VPWR _0127_ daisychain\[63\] clknet_5_26__leaf_clk sg13g2_dfrbpq_1
XFILLER_9_480 VPWR VGND sg13g2_decap_8
X_0898_ VPWR _0016_ state\[56\] VGND sg13g2_inv_1
XFILLER_28_502 VPWR VGND sg13g2_decap_8
XFILLER_28_579 VPWR VGND sg13g2_decap_8
XFILLER_11_424 VPWR VGND sg13g2_decap_8
XFILLER_23_251 VPWR VGND sg13g2_decap_8
XFILLER_7_406 VPWR VGND sg13g2_decap_8
XFILLER_23_76 VPWR VGND sg13g2_decap_8
XFILLER_3_634 VPWR VGND sg13g2_decap_8
XFILLER_2_144 VPWR VGND sg13g2_decap_8
XFILLER_48_84 VPWR VGND sg13g2_decap_8
XFILLER_0_14 VPWR VGND sg13g2_decap_8
XFILLER_46_343 VPWR VGND sg13g2_decap_8
XFILLER_14_251 VPWR VGND sg13g2_decap_8
XFILLER_42_560 VPWR VGND sg13g2_decap_8
X_0821_ VPWR _0210_ daisychain\[17\] VGND sg13g2_inv_1
X_0752_ _0355_ VPWR _0160_ VGND net94 _0000_ sg13g2_o21ai_1
XFILLER_9_67 VPWR VGND sg13g2_decap_8
X_0683_ net92 VPWR _0423_ VGND net70 state\[55\] sg13g2_o21ai_1
XFILLER_6_494 VPWR VGND sg13g2_decap_8
XFILLER_20_265 VPWR VGND sg13g2_decap_8
XFILLER_0_637 VPWR VGND sg13g2_decap_8
XFILLER_18_87 VPWR VGND sg13g2_decap_8
XFILLER_28_376 VPWR VGND sg13g2_decap_8
XFILLER_31_508 VPWR VGND sg13g2_decap_8
XFILLER_43_357 VPWR VGND sg13g2_decap_8
XFILLER_11_221 VPWR VGND sg13g2_decap_8
XFILLER_11_298 VPWR VGND sg13g2_decap_8
XFILLER_34_42 VPWR VGND sg13g2_decap_8
XFILLER_8_737 VPWR VGND sg13g2_fill_2
XFILLER_7_203 VPWR VGND sg13g2_decap_8
XFILLER_3_431 VPWR VGND sg13g2_decap_8
XFILLER_19_365 VPWR VGND sg13g2_decap_8
XFILLER_46_140 VPWR VGND sg13g2_decap_8
XFILLER_47_630 VPWR VGND sg13g2_decap_8
X_1020_ net119 VGND VPWR _0180_ state\[52\] clknet_5_12__leaf_clk sg13g2_dfrbpq_1
Xclkbuf_4_11_0_clk clknet_0_clk clknet_4_11_0_clk VPWR VGND sg13g2_buf_8
XFILLER_15_560 VPWR VGND sg13g2_decap_8
XFILLER_34_357 VPWR VGND sg13g2_decap_8
X_0804_ VPWR _0063_ state\[9\] VGND sg13g2_inv_1
X_0735_ _0304_ VPWR _0143_ VGND net91 _0038_ sg13g2_o21ai_1
XFILLER_41_0 VPWR VGND sg13g2_decap_8
X_0666_ _0114_ _0409_ _0410_ net53 _0243_ VPWR VGND sg13g2_a22oi_1
X_0597_ VGND VPWR net28 daisychain\[32\] _0359_ net49 sg13g2_a21oi_1
XFILLER_6_291 VPWR VGND sg13g2_decap_8
XFILLER_37_173 VPWR VGND sg13g2_decap_8
XFILLER_38_663 VPWR VGND sg13g2_fill_2
XFILLER_25_368 VPWR VGND sg13g2_decap_8
XFILLER_20_55 VPWR VGND sg13g2_decap_8
XFILLER_5_707 VPWR VGND sg13g2_fill_1
XFILLER_4_228 VPWR VGND sg13g2_decap_8
XFILLER_0_434 VPWR VGND sg13g2_decap_8
XFILLER_29_75 VPWR VGND sg13g2_decap_8
XFILLER_48_427 VPWR VGND sg13g2_decap_8
XFILLER_16_357 VPWR VGND sg13g2_decap_8
XFILLER_28_173 VPWR VGND sg13g2_decap_8
XFILLER_31_305 VPWR VGND sg13g2_decap_8
XFILLER_43_154 VPWR VGND sg13g2_decap_8
XFILLER_44_644 VPWR VGND sg13g2_decap_8
XFILLER_45_63 VPWR VGND sg13g2_decap_8
XANTENNA_6 VPWR VGND digitalen.g\[0\].u.OUTP sg13g2_antennanp
XFILLER_8_567 VPWR VGND sg13g2_decap_8
XFILLER_6_46 VPWR VGND sg13g2_decap_8
X_0520_ _0207_ net65 _0300_ _0301_ VPWR VGND sg13g2_a21o_1
XFILLER_13_4 VPWR VGND sg13g2_decap_4
XFILLER_19_162 VPWR VGND sg13g2_decap_8
XFILLER_35_666 VPWR VGND sg13g2_fill_1
XFILLER_39_427 VPWR VGND sg13g2_decap_8
X_1003_ net101 VGND VPWR _0163_ state\[35\] clknet_5_9__leaf_clk sg13g2_dfrbpq_1
XFILLER_22_349 VPWR VGND sg13g2_decap_8
XFILLER_30_382 VPWR VGND sg13g2_decap_8
XFILLER_34_154 VPWR VGND sg13g2_decap_8
X_0718_ VGND VPWR net32 daisychain\[62\] _0450_ net33 sg13g2_a21oi_1
X_0649_ VGND VPWR net29 daisychain\[45\] _0398_ net51 sg13g2_a21oi_1
XFILLER_13_349 VPWR VGND sg13g2_decap_8
XFILLER_25_165 VPWR VGND sg13g2_decap_8
XFILLER_26_644 VPWR VGND sg13g2_decap_8
XFILLER_15_77 VPWR VGND sg13g2_decap_8
XFILLER_21_360 VPWR VGND sg13g2_decap_8
XFILLER_31_32 VPWR VGND sg13g2_decap_8
XFILLER_40_168 VPWR VGND sg13g2_decap_8
XFILLER_5_515 VPWR VGND sg13g2_decap_8
XFILLER_0_231 VPWR VGND sg13g2_decap_8
Xoutput8 net8 uio_out[1] VPWR VGND sg13g2_buf_1
Xoutput21 net21 uo_out[6] VPWR VGND sg13g2_buf_1
Xoutput10 net10 uio_out[3] VPWR VGND sg13g2_buf_1
XFILLER_49_725 VPWR VGND sg13g2_decap_8
XFILLER_29_460 VPWR VGND sg13g2_decap_8
XFILLER_44_441 VPWR VGND sg13g2_decap_8
XFILLER_48_224 VPWR VGND sg13g2_decap_8
XFILLER_12_382 VPWR VGND sg13g2_decap_8
XFILLER_16_154 VPWR VGND sg13g2_decap_8
XFILLER_31_102 VPWR VGND sg13g2_decap_8
XFILLER_31_179 VPWR VGND sg13g2_decap_8
XFILLER_8_364 VPWR VGND sg13g2_decap_8
XFILLER_39_224 VPWR VGND sg13g2_decap_8
X_0503_ net87 VPWR _0288_ VGND net64 state\[10\] sg13g2_o21ai_1
XFILLER_4_592 VPWR VGND sg13g2_decap_8
XFILLER_23_636 VPWR VGND sg13g2_decap_8
XFILLER_27_419 VPWR VGND sg13g2_decap_8
XFILLER_35_496 VPWR VGND sg13g2_decap_8
XFILLER_48_791 VPWR VGND sg13g2_decap_8
XFILLER_10_319 VPWR VGND sg13g2_decap_8
XFILLER_22_146 VPWR VGND sg13g2_decap_8
XFILLER_31_691 VPWR VGND sg13g2_decap_8
XFILLER_2_529 VPWR VGND sg13g2_decap_8
XFILLER_45_238 VPWR VGND sg13g2_decap_8
XFILLER_46_717 VPWR VGND sg13g2_decap_8
Xclkbuf_5_23__f_clk clknet_5_23__leaf_clk clknet_4_11_0_clk VPWR VGND sg13g2_buf_16
XFILLER_13_146 VPWR VGND sg13g2_decap_8
XFILLER_14_658 VPWR VGND sg13g2_fill_1
XFILLER_26_441 VPWR VGND sg13g2_decap_8
XFILLER_26_98 VPWR VGND sg13g2_decap_8
XFILLER_41_455 VPWR VGND sg13g2_decap_8
XFILLER_42_42 VPWR VGND sg13g2_decap_8
XFILLER_6_802 VPWR VGND sg13g2_decap_8
XFILLER_5_389 VPWR VGND sg13g2_decap_8
XFILLER_5_312 VPWR VGND sg13g2_decap_8
XFILLER_1_595 VPWR VGND sg13g2_decap_8
XFILLER_3_25 VPWR VGND sg13g2_decap_8
XFILLER_49_522 VPWR VGND sg13g2_decap_8
XFILLER_17_430 VPWR VGND sg13g2_decap_8
XFILLER_49_599 VPWR VGND sg13g2_decap_8
XFILLER_32_466 VPWR VGND sg13g2_decap_8
X_0983_ net111 VGND VPWR _0143_ state\[15\] clknet_5_21__leaf_clk sg13g2_dfrbpq_1
XFILLER_8_161 VPWR VGND sg13g2_decap_8
Xfanout107 net108 net107 VPWR VGND sg13g2_buf_1
Xfanout118 net120 net118 VPWR VGND sg13g2_buf_1
XFILLER_27_216 VPWR VGND sg13g2_decap_8
XFILLER_10_116 VPWR VGND sg13g2_decap_8
XFILLER_11_606 VPWR VGND sg13g2_fill_2
XFILLER_11_639 VPWR VGND sg13g2_fill_2
XFILLER_23_433 VPWR VGND sg13g2_decap_8
XFILLER_35_293 VPWR VGND sg13g2_decap_8
XFILLER_12_67 VPWR VGND sg13g2_decap_8
XFILLER_6_109 VPWR VGND sg13g2_decap_8
XFILLER_2_326 VPWR VGND sg13g2_decap_8
XFILLER_18_227 VPWR VGND sg13g2_decap_8
XFILLER_33_219 VPWR VGND sg13g2_decap_8
XFILLER_37_75 VPWR VGND sg13g2_decap_8
XFILLER_46_525 VPWR VGND sg13g2_decap_8
XFILLER_14_433 VPWR VGND sg13g2_decap_8
XFILLER_41_252 VPWR VGND sg13g2_decap_8
XFILLER_45_7 VPWR VGND sg13g2_decap_8
XFILLER_6_687 VPWR VGND sg13g2_decap_8
XFILLER_5_186 VPWR VGND sg13g2_decap_8
XFILLER_1_392 VPWR VGND sg13g2_decap_8
XFILLER_37_503 VPWR VGND sg13g2_decap_8
XFILLER_49_396 VPWR VGND sg13g2_decap_8
XFILLER_24_219 VPWR VGND sg13g2_decap_8
XFILLER_32_263 VPWR VGND sg13g2_decap_8
XFILLER_20_447 VPWR VGND sg13g2_decap_8
X_0897_ VPWR _0248_ daisychain\[55\] VGND sg13g2_inv_1
X_0966_ net123 VGND VPWR _0126_ daisychain\[62\] clknet_5_24__leaf_clk sg13g2_dfrbpq_1
XFILLER_28_558 VPWR VGND sg13g2_decap_8
XFILLER_43_539 VPWR VGND sg13g2_decap_8
XFILLER_11_403 VPWR VGND sg13g2_decap_8
XFILLER_23_230 VPWR VGND sg13g2_decap_8
XFILLER_23_55 VPWR VGND sg13g2_decap_8
XFILLER_36_591 VPWR VGND sg13g2_decap_8
XFILLER_2_123 VPWR VGND sg13g2_decap_8
XFILLER_3_613 VPWR VGND sg13g2_decap_8
XFILLER_46_322 VPWR VGND sg13g2_decap_8
XFILLER_47_812 VPWR VGND sg13g2_decap_8
XFILLER_48_63 VPWR VGND sg13g2_decap_8
XFILLER_14_230 VPWR VGND sg13g2_decap_8
XFILLER_19_558 VPWR VGND sg13g2_fill_2
XFILLER_27_580 VPWR VGND sg13g2_decap_8
XFILLER_30_723 VPWR VGND sg13g2_fill_1
XFILLER_34_539 VPWR VGND sg13g2_decap_8
XFILLER_46_399 VPWR VGND sg13g2_decap_8
XFILLER_10_480 VPWR VGND sg13g2_decap_8
XFILLER_30_789 VPWR VGND sg13g2_decap_4
X_0820_ VPWR _0040_ state\[17\] VGND sg13g2_inv_1
X_0751_ _0352_ VPWR _0159_ VGND net85 _0056_ sg13g2_o21ai_1
XFILLER_9_46 VPWR VGND sg13g2_decap_8
XFILLER_2_690 VPWR VGND sg13g2_decap_8
X_0682_ _0118_ _0421_ _0422_ net48 _0247_ VPWR VGND sg13g2_a22oi_1
XFILLER_6_473 VPWR VGND sg13g2_decap_8
XFILLER_37_355 VPWR VGND sg13g2_decap_8
XFILLER_37_366 VPWR VGND sg13g2_fill_2
XFILLER_49_193 VPWR VGND sg13g2_decap_8
XFILLER_20_244 VPWR VGND sg13g2_decap_8
XFILLER_33_583 VPWR VGND sg13g2_decap_8
X_0949_ net118 VGND VPWR _0109_ daisychain\[45\] clknet_5_5__leaf_clk sg13g2_dfrbpq_1
XFILLER_0_616 VPWR VGND sg13g2_decap_8
XFILLER_47_119 VPWR VGND sg13g2_decap_8
XFILLER_48_609 VPWR VGND sg13g2_decap_8
XFILLER_16_539 VPWR VGND sg13g2_decap_8
XFILLER_18_66 VPWR VGND sg13g2_decap_8
XFILLER_28_355 VPWR VGND sg13g2_decap_8
XFILLER_34_21 VPWR VGND sg13g2_decap_8
XFILLER_43_336 VPWR VGND sg13g2_decap_8
XFILLER_11_200 VPWR VGND sg13g2_decap_8
XFILLER_11_277 VPWR VGND sg13g2_decap_8
XFILLER_24_594 VPWR VGND sg13g2_decap_8
XFILLER_34_98 VPWR VGND sg13g2_decap_8
XFILLER_7_259 VPWR VGND sg13g2_decap_8
XFILLER_1_0 VPWR VGND sg13g2_decap_8
XFILLER_3_410 VPWR VGND sg13g2_decap_8
XFILLER_3_487 VPWR VGND sg13g2_decap_8
XFILLER_15_8 VPWR VGND sg13g2_fill_1
XFILLER_19_344 VPWR VGND sg13g2_decap_8
XFILLER_38_119 VPWR VGND sg13g2_decap_8
XFILLER_47_686 VPWR VGND sg13g2_decap_8
XFILLER_34_336 VPWR VGND sg13g2_decap_8
XFILLER_46_196 VPWR VGND sg13g2_decap_8
X_0803_ VPWR _0201_ daisychain\[8\] VGND sg13g2_inv_1
X_0734_ _0301_ VPWR _0142_ VGND net91 _0037_ sg13g2_o21ai_1
X_0665_ VGND VPWR net30 daisychain\[49\] _0410_ net53 sg13g2_a21oi_1
XFILLER_7_771 VPWR VGND sg13g2_decap_8
XFILLER_6_270 VPWR VGND sg13g2_decap_8
XFILLER_34_0 VPWR VGND sg13g2_decap_8
XFILLER_38_620 VPWR VGND sg13g2_fill_1
X_0596_ _0226_ net72 _0357_ _0358_ VPWR VGND sg13g2_a21o_1
XFILLER_1_91 VPWR VGND sg13g2_decap_8
XFILLER_25_347 VPWR VGND sg13g2_decap_8
XFILLER_26_804 VPWR VGND sg13g2_fill_1
XFILLER_26_815 VPWR VGND sg13g2_decap_8
XFILLER_37_152 VPWR VGND sg13g2_decap_8
Xclkbuf_5_4__f_clk clknet_5_4__leaf_clk clknet_4_2_0_clk VPWR VGND sg13g2_buf_16
XFILLER_21_542 VPWR VGND sg13g2_fill_1
XFILLER_21_597 VPWR VGND sg13g2_decap_8
XFILLER_33_380 VPWR VGND sg13g2_decap_8
XFILLER_0_413 VPWR VGND sg13g2_decap_8
XFILLER_20_34 VPWR VGND sg13g2_decap_8
XFILLER_4_207 VPWR VGND sg13g2_decap_8
XFILLER_28_152 VPWR VGND sg13g2_decap_8
XFILLER_29_54 VPWR VGND sg13g2_decap_8
XFILLER_44_623 VPWR VGND sg13g2_decap_8
XFILLER_48_406 VPWR VGND sg13g2_decap_8
XFILLER_12_564 VPWR VGND sg13g2_decap_4
XFILLER_16_336 VPWR VGND sg13g2_decap_8
XFILLER_24_380 VPWR VGND sg13g2_decap_8
XFILLER_43_133 VPWR VGND sg13g2_decap_8
XFILLER_45_42 VPWR VGND sg13g2_decap_8
XFILLER_8_546 VPWR VGND sg13g2_decap_8
XFILLER_6_25 VPWR VGND sg13g2_decap_8
XFILLER_39_406 VPWR VGND sg13g2_decap_8
XFILLER_3_284 VPWR VGND sg13g2_decap_8
XFILLER_19_141 VPWR VGND sg13g2_decap_8
XFILLER_23_818 VPWR VGND sg13g2_decap_4
XFILLER_34_133 VPWR VGND sg13g2_decap_8
XFILLER_35_601 VPWR VGND sg13g2_fill_1
XFILLER_35_645 VPWR VGND sg13g2_fill_2
XFILLER_47_483 VPWR VGND sg13g2_decap_8
X_1002_ net113 VGND VPWR _0162_ state\[34\] clknet_5_2__leaf_clk sg13g2_dfrbpq_1
XFILLER_22_328 VPWR VGND sg13g2_decap_8
XFILLER_30_361 VPWR VGND sg13g2_decap_8
X_0717_ _0256_ net56 _0448_ _0449_ VPWR VGND sg13g2_a21o_1
X_0648_ _0239_ net74 _0396_ _0397_ VPWR VGND sg13g2_a21o_1
XFILLER_26_623 VPWR VGND sg13g2_decap_8
XFILLER_38_472 VPWR VGND sg13g2_decap_8
XFILLER_38_483 VPWR VGND sg13g2_fill_1
X_0579_ net84 VPWR _0345_ VGND net61 state\[29\] sg13g2_o21ai_1
XFILLER_13_328 VPWR VGND sg13g2_decap_8
XFILLER_15_56 VPWR VGND sg13g2_decap_8
XFILLER_25_144 VPWR VGND sg13g2_decap_8
XFILLER_40_147 VPWR VGND sg13g2_decap_8
XFILLER_41_626 VPWR VGND sg13g2_decap_8
XFILLER_41_648 VPWR VGND sg13g2_fill_2
XFILLER_31_11 VPWR VGND sg13g2_decap_8
XFILLER_31_88 VPWR VGND sg13g2_decap_8
Xclkbuf_4_10_0_clk clknet_0_clk clknet_4_10_0_clk VPWR VGND sg13g2_buf_8
XFILLER_0_210 VPWR VGND sg13g2_decap_8
XFILLER_0_287 VPWR VGND sg13g2_decap_8
XFILLER_1_700 VPWR VGND sg13g2_decap_4
XFILLER_48_203 VPWR VGND sg13g2_decap_8
Xoutput9 net9 uio_out[2] VPWR VGND sg13g2_buf_1
Xoutput22 net22 uo_out[7] VPWR VGND sg13g2_buf_1
Xoutput11 net11 uio_out[4] VPWR VGND sg13g2_buf_1
XFILLER_49_704 VPWR VGND sg13g2_decap_8
XFILLER_16_133 VPWR VGND sg13g2_decap_8
XFILLER_17_645 VPWR VGND sg13g2_fill_1
XFILLER_17_656 VPWR VGND sg13g2_fill_2
XFILLER_36_409 VPWR VGND sg13g2_decap_8
XFILLER_44_420 VPWR VGND sg13g2_decap_8
XFILLER_12_361 VPWR VGND sg13g2_decap_8
XFILLER_31_158 VPWR VGND sg13g2_decap_8
XFILLER_44_497 VPWR VGND sg13g2_decap_8
XFILLER_8_343 VPWR VGND sg13g2_decap_8
X_0502_ _0073_ _0286_ _0287_ net40 _0202_ VPWR VGND sg13g2_a22oi_1
XFILLER_4_571 VPWR VGND sg13g2_decap_8
XFILLER_39_203 VPWR VGND sg13g2_decap_8
XFILLER_48_770 VPWR VGND sg13g2_decap_8
XFILLER_22_125 VPWR VGND sg13g2_decap_8
XFILLER_23_615 VPWR VGND sg13g2_decap_8
XFILLER_35_475 VPWR VGND sg13g2_decap_8
XFILLER_47_280 VPWR VGND sg13g2_decap_8
XFILLER_2_508 VPWR VGND sg13g2_decap_8
XFILLER_18_409 VPWR VGND sg13g2_decap_8
XFILLER_26_420 VPWR VGND sg13g2_decap_8
XFILLER_38_280 VPWR VGND sg13g2_decap_8
XFILLER_45_217 VPWR VGND sg13g2_decap_8
XFILLER_46_707 VPWR VGND sg13g2_fill_2
XFILLER_13_125 VPWR VGND sg13g2_decap_8
XFILLER_26_497 VPWR VGND sg13g2_decap_8
XFILLER_26_77 VPWR VGND sg13g2_decap_8
XFILLER_41_434 VPWR VGND sg13g2_decap_8
XFILLER_42_21 VPWR VGND sg13g2_decap_8
XFILLER_42_98 VPWR VGND sg13g2_decap_8
XFILLER_5_368 VPWR VGND sg13g2_decap_8
XFILLER_1_574 VPWR VGND sg13g2_decap_8
XFILLER_37_707 VPWR VGND sg13g2_fill_1
XFILLER_49_578 VPWR VGND sg13g2_decap_8
XFILLER_49_501 VPWR VGND sg13g2_decap_8
XFILLER_17_486 VPWR VGND sg13g2_decap_8
XFILLER_32_445 VPWR VGND sg13g2_decap_8
XFILLER_36_239 VPWR VGND sg13g2_decap_8
XFILLER_44_294 VPWR VGND sg13g2_decap_8
X_0982_ net111 VGND VPWR _0142_ state\[14\] clknet_5_17__leaf_clk sg13g2_dfrbpq_1
XFILLER_9_641 VPWR VGND sg13g2_decap_4
XFILLER_8_140 VPWR VGND sg13g2_decap_8
Xfanout108 net111 net108 VPWR VGND sg13g2_buf_1
Xfanout119 net120 net119 VPWR VGND sg13g2_buf_1
XFILLER_11_618 VPWR VGND sg13g2_fill_1
XFILLER_23_412 VPWR VGND sg13g2_decap_8
XFILLER_23_489 VPWR VGND sg13g2_decap_8
XFILLER_35_272 VPWR VGND sg13g2_decap_8
XFILLER_12_46 VPWR VGND sg13g2_decap_8
XFILLER_2_305 VPWR VGND sg13g2_decap_8
XFILLER_3_817 VPWR VGND sg13g2_decap_4
XFILLER_18_206 VPWR VGND sg13g2_decap_8
XFILLER_46_504 VPWR VGND sg13g2_decap_8
XFILLER_14_412 VPWR VGND sg13g2_decap_8
XFILLER_26_294 VPWR VGND sg13g2_decap_8
XFILLER_27_762 VPWR VGND sg13g2_decap_8
XFILLER_37_54 VPWR VGND sg13g2_decap_8
XFILLER_41_231 VPWR VGND sg13g2_decap_8
XFILLER_14_489 VPWR VGND sg13g2_decap_8
XFILLER_42_776 VPWR VGND sg13g2_fill_1
XFILLER_6_622 VPWR VGND sg13g2_fill_1
XFILLER_1_371 VPWR VGND sg13g2_decap_8
XFILLER_38_7 VPWR VGND sg13g2_decap_8
XFILLER_5_165 VPWR VGND sg13g2_decap_8
XFILLER_37_559 VPWR VGND sg13g2_decap_8
XFILLER_49_375 VPWR VGND sg13g2_decap_8
XFILLER_17_283 VPWR VGND sg13g2_decap_8
XFILLER_20_426 VPWR VGND sg13g2_decap_8
XFILLER_32_242 VPWR VGND sg13g2_decap_8
XFILLER_33_743 VPWR VGND sg13g2_fill_1
XFILLER_45_581 VPWR VGND sg13g2_decap_8
X_0896_ VPWR _0015_ state\[55\] VGND sg13g2_inv_1
X_0965_ net123 VGND VPWR _0125_ daisychain\[61\] clknet_5_26__leaf_clk sg13g2_dfrbpq_1
XFILLER_28_537 VPWR VGND sg13g2_decap_8
XFILLER_36_570 VPWR VGND sg13g2_decap_8
XFILLER_43_518 VPWR VGND sg13g2_decap_8
XFILLER_11_459 VPWR VGND sg13g2_decap_8
XFILLER_23_286 VPWR VGND sg13g2_decap_8
XFILLER_2_102 VPWR VGND sg13g2_decap_8
XFILLER_2_179 VPWR VGND sg13g2_decap_8
XFILLER_3_4 VPWR VGND sg13g2_decap_8
XFILLER_3_669 VPWR VGND sg13g2_decap_4
XFILLER_0_49 VPWR VGND sg13g2_decap_8
XFILLER_19_526 VPWR VGND sg13g2_decap_8
XFILLER_19_537 VPWR VGND sg13g2_fill_1
XFILLER_46_301 VPWR VGND sg13g2_decap_8
XFILLER_48_42 VPWR VGND sg13g2_decap_8
XFILLER_14_286 VPWR VGND sg13g2_decap_8
XFILLER_15_721 VPWR VGND sg13g2_fill_1
XFILLER_15_732 VPWR VGND sg13g2_decap_8
XFILLER_15_743 VPWR VGND sg13g2_fill_1
XFILLER_30_713 VPWR VGND sg13g2_fill_2
XFILLER_34_518 VPWR VGND sg13g2_decap_8
XFILLER_42_595 VPWR VGND sg13g2_decap_8
XFILLER_46_378 VPWR VGND sg13g2_decap_8
XFILLER_9_25 VPWR VGND sg13g2_decap_8
XFILLER_30_768 VPWR VGND sg13g2_fill_2
Xfanout90 net91 net90 VPWR VGND sg13g2_buf_1
X_0750_ _0349_ VPWR _0158_ VGND net85 _0055_ sg13g2_o21ai_1
X_0681_ VGND VPWR net31 daisychain\[53\] _0422_ net48 sg13g2_a21oi_1
XFILLER_6_452 VPWR VGND sg13g2_decap_8
XFILLER_25_529 VPWR VGND sg13g2_decap_8
XFILLER_37_334 VPWR VGND sg13g2_decap_8
XFILLER_49_172 VPWR VGND sg13g2_decap_8
XFILLER_20_223 VPWR VGND sg13g2_decap_8
XFILLER_33_562 VPWR VGND sg13g2_decap_8
X_0948_ net117 VGND VPWR _0108_ daisychain\[44\] clknet_5_5__leaf_clk sg13g2_dfrbpq_1
X_0879_ VPWR _0239_ daisychain\[46\] VGND sg13g2_inv_1
XFILLER_18_45 VPWR VGND sg13g2_decap_8
XFILLER_28_334 VPWR VGND sg13g2_decap_8
XFILLER_44_805 VPWR VGND sg13g2_decap_4
XFILLER_16_518 VPWR VGND sg13g2_decap_8
XFILLER_24_573 VPWR VGND sg13g2_decap_8
XFILLER_34_77 VPWR VGND sg13g2_decap_8
XFILLER_43_315 VPWR VGND sg13g2_decap_8
XFILLER_11_256 VPWR VGND sg13g2_decap_8
XFILLER_7_238 VPWR VGND sg13g2_decap_8
XFILLER_3_466 VPWR VGND sg13g2_decap_8
XFILLER_19_323 VPWR VGND sg13g2_decap_8
XFILLER_34_315 VPWR VGND sg13g2_decap_8
XFILLER_46_175 VPWR VGND sg13g2_decap_8
XFILLER_47_665 VPWR VGND sg13g2_decap_8
XFILLER_30_543 VPWR VGND sg13g2_decap_8
XFILLER_30_554 VPWR VGND sg13g2_fill_2
XFILLER_30_576 VPWR VGND sg13g2_decap_4
XFILLER_42_392 VPWR VGND sg13g2_decap_8
X_0802_ VPWR _0062_ state\[8\] VGND sg13g2_inv_1
X_0733_ _0298_ VPWR _0141_ VGND net88 _0036_ sg13g2_o21ai_1
X_0664_ _0243_ net76 _0408_ _0409_ VPWR VGND sg13g2_a21o_1
XFILLER_7_794 VPWR VGND sg13g2_decap_4
XFILLER_37_131 VPWR VGND sg13g2_decap_8
X_0595_ net94 VPWR _0357_ VGND net72 state\[33\] sg13g2_o21ai_1
XFILLER_1_70 VPWR VGND sg13g2_decap_8
XFILLER_21_521 VPWR VGND sg13g2_decap_8
XFILLER_25_326 VPWR VGND sg13g2_decap_8
XFILLER_40_329 VPWR VGND sg13g2_decap_8
XFILLER_21_576 VPWR VGND sg13g2_decap_8
XFILLER_0_469 VPWR VGND sg13g2_decap_8
XFILLER_29_33 VPWR VGND sg13g2_decap_8
XFILLER_16_315 VPWR VGND sg13g2_decap_8
XFILLER_28_131 VPWR VGND sg13g2_decap_8
XFILLER_29_621 VPWR VGND sg13g2_decap_8
XFILLER_29_632 VPWR VGND sg13g2_fill_1
XFILLER_43_112 VPWR VGND sg13g2_decap_8
XFILLER_44_602 VPWR VGND sg13g2_decap_8
XFILLER_45_21 VPWR VGND sg13g2_decap_8
Xdigitalen.g\[2\].u.inv1 VPWR digitalen.g\[2\].u.OUTN net6 VGND sg13g2_inv_1
XFILLER_12_543 VPWR VGND sg13g2_decap_8
XFILLER_32_819 VPWR VGND sg13g2_decap_4
XFILLER_43_189 VPWR VGND sg13g2_decap_8
XFILLER_45_98 VPWR VGND sg13g2_decap_8
XFILLER_8_525 VPWR VGND sg13g2_decap_8
XFILLER_3_263 VPWR VGND sg13g2_decap_8
XFILLER_4_731 VPWR VGND sg13g2_fill_2
XFILLER_19_120 VPWR VGND sg13g2_decap_8
XFILLER_19_197 VPWR VGND sg13g2_decap_8
XFILLER_22_307 VPWR VGND sg13g2_decap_8
XFILLER_34_112 VPWR VGND sg13g2_decap_8
XFILLER_34_189 VPWR VGND sg13g2_decap_8
XFILLER_35_635 VPWR VGND sg13g2_fill_1
XFILLER_47_462 VPWR VGND sg13g2_decap_8
X_1001_ net113 VGND VPWR _0161_ state\[33\] clknet_5_3__leaf_clk sg13g2_dfrbpq_1
XFILLER_15_392 VPWR VGND sg13g2_decap_8
XFILLER_30_340 VPWR VGND sg13g2_decap_8
X_0716_ net80 VPWR _0448_ VGND net56 state\[63\] sg13g2_o21ai_1
X_0647_ net96 VPWR _0396_ VGND net74 state\[46\] sg13g2_o21ai_1
X_0578_ _0092_ _0343_ _0344_ net37 _0221_ VPWR VGND sg13g2_a22oi_1
XFILLER_25_123 VPWR VGND sg13g2_decap_8
XFILLER_26_602 VPWR VGND sg13g2_decap_8
XFILLER_38_451 VPWR VGND sg13g2_decap_8
XFILLER_13_307 VPWR VGND sg13g2_decap_8
XFILLER_15_35 VPWR VGND sg13g2_decap_8
XFILLER_40_126 VPWR VGND sg13g2_decap_8
XFILLER_41_616 VPWR VGND sg13g2_fill_2
XFILLER_21_395 VPWR VGND sg13g2_decap_8
XFILLER_31_67 VPWR VGND sg13g2_decap_8
Xoutput12 net12 uio_out[5] VPWR VGND sg13g2_buf_1
XFILLER_0_266 VPWR VGND sg13g2_decap_8
XFILLER_48_259 VPWR VGND sg13g2_decap_8
XFILLER_16_112 VPWR VGND sg13g2_decap_8
XFILLER_16_189 VPWR VGND sg13g2_decap_8
XFILLER_29_495 VPWR VGND sg13g2_decap_8
XFILLER_32_638 VPWR VGND sg13g2_fill_1
XFILLER_44_476 VPWR VGND sg13g2_decap_8
XFILLER_12_340 VPWR VGND sg13g2_decap_8
XFILLER_31_137 VPWR VGND sg13g2_decap_8
XFILLER_8_322 VPWR VGND sg13g2_decap_8
X_0501_ VGND VPWR net25 daisychain\[8\] _0287_ net40 sg13g2_a21oi_1
XFILLER_8_399 VPWR VGND sg13g2_decap_8
XFILLER_4_550 VPWR VGND sg13g2_decap_8
XFILLER_39_259 VPWR VGND sg13g2_decap_8
XFILLER_22_104 VPWR VGND sg13g2_decap_8
XFILLER_35_454 VPWR VGND sg13g2_decap_8
XFILLER_7_91 VPWR VGND sg13g2_decap_8
XFILLER_13_104 VPWR VGND sg13g2_decap_8
XFILLER_26_476 VPWR VGND sg13g2_decap_8
XFILLER_26_56 VPWR VGND sg13g2_decap_8
XFILLER_41_413 VPWR VGND sg13g2_decap_8
XFILLER_14_649 VPWR VGND sg13g2_decap_8
XFILLER_21_192 VPWR VGND sg13g2_decap_8
XFILLER_22_682 VPWR VGND sg13g2_decap_8
XFILLER_22_693 VPWR VGND sg13g2_fill_2
XFILLER_42_77 VPWR VGND sg13g2_decap_8
XFILLER_1_553 VPWR VGND sg13g2_decap_8
XFILLER_5_347 VPWR VGND sg13g2_decap_8
XFILLER_36_218 VPWR VGND sg13g2_decap_8
XFILLER_49_557 VPWR VGND sg13g2_decap_8
XFILLER_17_465 VPWR VGND sg13g2_decap_8
XFILLER_29_292 VPWR VGND sg13g2_decap_8
XFILLER_32_424 VPWR VGND sg13g2_decap_8
XFILLER_44_273 VPWR VGND sg13g2_decap_8
XFILLER_45_785 VPWR VGND sg13g2_decap_4
X_0981_ net108 VGND VPWR _0141_ state\[13\] clknet_5_17__leaf_clk sg13g2_dfrbpq_1
XFILLER_9_686 VPWR VGND sg13g2_fill_2
XFILLER_8_196 VPWR VGND sg13g2_decap_8
Xfanout109 net111 net109 VPWR VGND sg13g2_buf_1
XFILLER_35_251 VPWR VGND sg13g2_decap_8
XFILLER_12_25 VPWR VGND sg13g2_decap_8
XFILLER_23_468 VPWR VGND sg13g2_decap_8
XFILLER_14_468 VPWR VGND sg13g2_decap_8
XFILLER_26_273 VPWR VGND sg13g2_decap_8
XFILLER_41_210 VPWR VGND sg13g2_decap_8
XFILLER_42_799 VPWR VGND sg13g2_fill_2
XFILLER_41_287 VPWR VGND sg13g2_decap_8
XFILLER_5_144 VPWR VGND sg13g2_decap_8
XFILLER_1_350 VPWR VGND sg13g2_decap_8
XFILLER_17_262 VPWR VGND sg13g2_decap_8
XFILLER_37_538 VPWR VGND sg13g2_decap_8
XFILLER_45_560 VPWR VGND sg13g2_decap_8
XFILLER_49_354 VPWR VGND sg13g2_decap_8
XFILLER_20_405 VPWR VGND sg13g2_decap_8
XFILLER_32_221 VPWR VGND sg13g2_decap_8
XFILLER_32_298 VPWR VGND sg13g2_decap_8
X_0964_ net123 VGND VPWR _0124_ daisychain\[60\] clknet_5_0__leaf_clk sg13g2_dfrbpq_1
X_0895_ VPWR _0247_ daisychain\[54\] VGND sg13g2_inv_1
XFILLER_9_494 VPWR VGND sg13g2_decap_8
XFILLER_28_516 VPWR VGND sg13g2_decap_8
XFILLER_4_81 VPWR VGND sg13g2_decap_8
XFILLER_23_265 VPWR VGND sg13g2_decap_8
XFILLER_24_722 VPWR VGND sg13g2_fill_1
XFILLER_11_438 VPWR VGND sg13g2_decap_8
XFILLER_23_13 VPWR VGND sg13g2_fill_2
XFILLER_2_158 VPWR VGND sg13g2_decap_8
XFILLER_3_648 VPWR VGND sg13g2_decap_8
XFILLER_48_21 VPWR VGND sg13g2_decap_8
XFILLER_0_28 VPWR VGND sg13g2_decap_8
XFILLER_19_505 VPWR VGND sg13g2_decap_8
XFILLER_46_357 VPWR VGND sg13g2_decap_8
XFILLER_48_98 VPWR VGND sg13g2_decap_8
XFILLER_14_265 VPWR VGND sg13g2_decap_8
XFILLER_30_703 VPWR VGND sg13g2_decap_4
XFILLER_42_574 VPWR VGND sg13g2_decap_8
Xfanout91 net100 net91 VPWR VGND sg13g2_buf_1
Xfanout80 net4 net80 VPWR VGND sg13g2_buf_1
XFILLER_13_90 VPWR VGND sg13g2_decap_8
X_0680_ _0247_ net71 _0420_ _0421_ VPWR VGND sg13g2_a21o_1
XFILLER_6_431 VPWR VGND sg13g2_decap_8
XFILLER_29_4 VPWR VGND sg13g2_decap_4
XFILLER_37_313 VPWR VGND sg13g2_decap_8
XFILLER_49_151 VPWR VGND sg13g2_decap_8
XFILLER_25_508 VPWR VGND sg13g2_decap_8
XFILLER_33_541 VPWR VGND sg13g2_decap_8
XFILLER_20_202 VPWR VGND sg13g2_decap_8
XFILLER_20_279 VPWR VGND sg13g2_decap_8
X_0947_ net117 VGND VPWR _0107_ daisychain\[43\] clknet_5_4__leaf_clk sg13g2_dfrbpq_1
XFILLER_9_291 VPWR VGND sg13g2_decap_8
X_0878_ VPWR _0005_ state\[46\] VGND sg13g2_inv_1
XFILLER_18_13 VPWR VGND sg13g2_decap_8
XFILLER_28_313 VPWR VGND sg13g2_decap_8
XFILLER_11_235 VPWR VGND sg13g2_decap_8
XFILLER_24_552 VPWR VGND sg13g2_decap_8
XFILLER_34_56 VPWR VGND sg13g2_decap_8
XFILLER_20_791 VPWR VGND sg13g2_fill_1
XFILLER_3_445 VPWR VGND sg13g2_decap_8
XFILLER_7_217 VPWR VGND sg13g2_decap_8
XFILLER_19_302 VPWR VGND sg13g2_decap_8
Xclkbuf_5_29__f_clk clknet_5_29__leaf_clk clknet_4_14_0_clk VPWR VGND sg13g2_buf_16
XFILLER_19_379 VPWR VGND sg13g2_decap_8
XFILLER_46_154 VPWR VGND sg13g2_decap_8
XFILLER_47_644 VPWR VGND sg13g2_decap_8
XFILLER_15_574 VPWR VGND sg13g2_decap_8
XFILLER_30_522 VPWR VGND sg13g2_decap_8
XFILLER_42_371 VPWR VGND sg13g2_decap_8
X_0801_ VPWR _0200_ daisychain\[7\] VGND sg13g2_inv_1
X_0732_ _0295_ VPWR _0140_ VGND net88 _0035_ sg13g2_o21ai_1
X_0663_ net98 VPWR _0408_ VGND net76 state\[50\] sg13g2_o21ai_1
X_0594_ _0096_ _0355_ _0356_ net46 _0225_ VPWR VGND sg13g2_a22oi_1
XFILLER_25_305 VPWR VGND sg13g2_decap_8
XFILLER_37_110 VPWR VGND sg13g2_decap_8
XFILLER_21_500 VPWR VGND sg13g2_decap_8
XFILLER_21_555 VPWR VGND sg13g2_decap_8
XFILLER_37_187 VPWR VGND sg13g2_decap_8
XFILLER_40_308 VPWR VGND sg13g2_decap_8
XFILLER_0_448 VPWR VGND sg13g2_decap_8
XFILLER_20_69 VPWR VGND sg13g2_decap_8
XFILLER_29_600 VPWR VGND sg13g2_decap_8
XFILLER_28_110 VPWR VGND sg13g2_decap_8
XFILLER_28_187 VPWR VGND sg13g2_decap_8
XFILLER_29_677 VPWR VGND sg13g2_fill_2
XFILLER_29_89 VPWR VGND sg13g2_decap_8
XFILLER_43_168 VPWR VGND sg13g2_decap_8
XFILLER_44_658 VPWR VGND sg13g2_decap_8
XFILLER_44_669 VPWR VGND sg13g2_fill_1
XFILLER_45_77 VPWR VGND sg13g2_decap_8
Xdigitalen.g\[2\].u.inv2 VPWR digitalen.g\[2\].u.OUTP digitalen.g\[2\].u.OUTN VGND
+ sg13g2_inv_1
XFILLER_12_522 VPWR VGND sg13g2_decap_8
XFILLER_31_319 VPWR VGND sg13g2_decap_8
XFILLER_8_504 VPWR VGND sg13g2_decap_8
XFILLER_3_242 VPWR VGND sg13g2_decap_8
XFILLER_47_441 VPWR VGND sg13g2_decap_8
X_1000_ net113 VGND VPWR _0160_ state\[32\] clknet_5_3__leaf_clk sg13g2_dfrbpq_1
XFILLER_15_371 VPWR VGND sg13g2_decap_8
XFILLER_19_176 VPWR VGND sg13g2_decap_8
XFILLER_31_820 VPWR VGND sg13g2_fill_2
XFILLER_34_168 VPWR VGND sg13g2_decap_8
XFILLER_35_647 VPWR VGND sg13g2_fill_1
XFILLER_30_396 VPWR VGND sg13g2_decap_8
X_0715_ _0126_ _0446_ _0447_ net33 _0255_ VPWR VGND sg13g2_a22oi_1
XFILLER_7_581 VPWR VGND sg13g2_decap_8
Xclkbuf_5_12__f_clk clknet_5_12__leaf_clk clknet_4_6_0_clk VPWR VGND sg13g2_buf_16
X_0646_ _0109_ _0394_ _0395_ net51 _0238_ VPWR VGND sg13g2_a22oi_1
X_0577_ VGND VPWR net24 daisychain\[27\] _0344_ net37 sg13g2_a21oi_1
XFILLER_25_102 VPWR VGND sg13g2_decap_8
XFILLER_26_658 VPWR VGND sg13g2_decap_8
XFILLER_26_669 VPWR VGND sg13g2_fill_1
XFILLER_38_430 VPWR VGND sg13g2_decap_8
XFILLER_21_374 VPWR VGND sg13g2_decap_8
XFILLER_22_820 VPWR VGND sg13g2_fill_2
XFILLER_25_179 VPWR VGND sg13g2_decap_8
XFILLER_40_105 VPWR VGND sg13g2_decap_8
XFILLER_31_46 VPWR VGND sg13g2_decap_8
Xoutput13 net13 uio_out[6] VPWR VGND sg13g2_buf_1
XFILLER_5_529 VPWR VGND sg13g2_decap_8
XFILLER_0_245 VPWR VGND sg13g2_decap_8
XFILLER_48_238 VPWR VGND sg13g2_decap_8
XFILLER_49_739 VPWR VGND sg13g2_decap_8
XFILLER_16_168 VPWR VGND sg13g2_decap_8
XFILLER_17_658 VPWR VGND sg13g2_fill_1
XFILLER_17_669 VPWR VGND sg13g2_decap_8
XFILLER_25_691 VPWR VGND sg13g2_decap_4
XFILLER_29_474 VPWR VGND sg13g2_decap_8
XFILLER_31_116 VPWR VGND sg13g2_decap_8
XFILLER_44_455 VPWR VGND sg13g2_decap_8
XFILLER_12_396 VPWR VGND sg13g2_decap_8
XFILLER_40_650 VPWR VGND sg13g2_fill_1
XFILLER_8_378 VPWR VGND sg13g2_decap_8
XFILLER_8_301 VPWR VGND sg13g2_decap_8
X_0500_ _0202_ net60 _0285_ _0286_ VPWR VGND sg13g2_a21o_1
XFILLER_11_4 VPWR VGND sg13g2_decap_8
XFILLER_35_433 VPWR VGND sg13g2_decap_8
XFILLER_39_238 VPWR VGND sg13g2_decap_8
XFILLER_30_193 VPWR VGND sg13g2_decap_8
XFILLER_7_70 VPWR VGND sg13g2_decap_8
X_0629_ VGND VPWR net29 daisychain\[40\] _0383_ net50 sg13g2_a21oi_1
XFILLER_26_35 VPWR VGND sg13g2_decap_8
XFILLER_26_455 VPWR VGND sg13g2_decap_8
XFILLER_21_171 VPWR VGND sg13g2_decap_8
XFILLER_22_650 VPWR VGND sg13g2_fill_2
XFILLER_41_469 VPWR VGND sg13g2_decap_8
XFILLER_42_56 VPWR VGND sg13g2_decap_8
XFILLER_9_109 VPWR VGND sg13g2_decap_8
XFILLER_5_326 VPWR VGND sg13g2_decap_8
XFILLER_1_532 VPWR VGND sg13g2_decap_8
XFILLER_3_39 VPWR VGND sg13g2_decap_8
XFILLER_17_444 VPWR VGND sg13g2_decap_8
XFILLER_29_271 VPWR VGND sg13g2_decap_8
XFILLER_49_536 VPWR VGND sg13g2_decap_8
XFILLER_32_403 VPWR VGND sg13g2_decap_8
XFILLER_44_252 VPWR VGND sg13g2_decap_8
X_0980_ net108 VGND VPWR _0140_ state\[12\] clknet_5_16__leaf_clk sg13g2_dfrbpq_1
XFILLER_12_193 VPWR VGND sg13g2_decap_8
XFILLER_8_175 VPWR VGND sg13g2_decap_8
XFILLER_23_447 VPWR VGND sg13g2_decap_8
XFILLER_35_230 VPWR VGND sg13g2_decap_8
XFILLER_31_480 VPWR VGND sg13g2_decap_8
XFILLER_37_89 VPWR VGND sg13g2_decap_8
XFILLER_46_539 VPWR VGND sg13g2_decap_8
XFILLER_14_447 VPWR VGND sg13g2_decap_8
XFILLER_26_252 VPWR VGND sg13g2_decap_8
XFILLER_41_266 VPWR VGND sg13g2_decap_8
XFILLER_10_653 VPWR VGND sg13g2_decap_4
XFILLER_10_697 VPWR VGND sg13g2_fill_2
XFILLER_6_613 VPWR VGND sg13g2_decap_8
XFILLER_5_123 VPWR VGND sg13g2_decap_8
XFILLER_49_333 VPWR VGND sg13g2_decap_8
XFILLER_17_241 VPWR VGND sg13g2_decap_8
XFILLER_32_200 VPWR VGND sg13g2_decap_8
XFILLER_37_517 VPWR VGND sg13g2_decap_8
XFILLER_32_277 VPWR VGND sg13g2_decap_8
X_0894_ VPWR _0014_ state\[54\] VGND sg13g2_inv_1
X_0963_ net123 VGND VPWR _0123_ daisychain\[59\] clknet_5_0__leaf_clk sg13g2_dfrbpq_1
XFILLER_9_473 VPWR VGND sg13g2_decap_8
XFILLER_4_60 VPWR VGND sg13g2_decap_8
XFILLER_11_417 VPWR VGND sg13g2_decap_8
XFILLER_23_244 VPWR VGND sg13g2_decap_8
XFILLER_23_69 VPWR VGND sg13g2_decap_8
XFILLER_3_627 VPWR VGND sg13g2_decap_8
XFILLER_2_137 VPWR VGND sg13g2_decap_8
XFILLER_27_594 VPWR VGND sg13g2_decap_8
XFILLER_46_336 VPWR VGND sg13g2_decap_8
XFILLER_48_77 VPWR VGND sg13g2_decap_8
XFILLER_14_244 VPWR VGND sg13g2_decap_8
XFILLER_30_715 VPWR VGND sg13g2_fill_1
XFILLER_42_553 VPWR VGND sg13g2_decap_8
Xfanout92 net99 net92 VPWR VGND sg13g2_buf_1
Xfanout81 net100 net81 VPWR VGND sg13g2_buf_1
Xfanout70 net72 net70 VPWR VGND sg13g2_buf_1
XFILLER_6_410 VPWR VGND sg13g2_decap_8
XFILLER_10_494 VPWR VGND sg13g2_decap_8
XFILLER_43_7 VPWR VGND sg13g2_decap_8
XFILLER_6_487 VPWR VGND sg13g2_decap_8
XFILLER_49_130 VPWR VGND sg13g2_decap_8
XFILLER_18_561 VPWR VGND sg13g2_fill_1
XFILLER_18_594 VPWR VGND sg13g2_fill_2
XFILLER_33_520 VPWR VGND sg13g2_decap_8
XFILLER_20_258 VPWR VGND sg13g2_decap_8
X_0877_ VPWR _0238_ daisychain\[45\] VGND sg13g2_inv_1
X_0946_ net113 VGND VPWR _0106_ daisychain\[42\] clknet_5_3__leaf_clk sg13g2_dfrbpq_1
XFILLER_9_270 VPWR VGND sg13g2_decap_8
XFILLER_28_369 VPWR VGND sg13g2_decap_8
XFILLER_11_214 VPWR VGND sg13g2_decap_8
XFILLER_12_704 VPWR VGND sg13g2_fill_1
XFILLER_12_737 VPWR VGND sg13g2_fill_1
XFILLER_24_531 VPWR VGND sg13g2_decap_8
XFILLER_34_35 VPWR VGND sg13g2_decap_8
XFILLER_3_424 VPWR VGND sg13g2_decap_8
XFILLER_46_133 VPWR VGND sg13g2_decap_8
XFILLER_47_623 VPWR VGND sg13g2_decap_8
XFILLER_15_553 VPWR VGND sg13g2_decap_8
XFILLER_19_358 VPWR VGND sg13g2_decap_8
XFILLER_27_391 VPWR VGND sg13g2_decap_8
XFILLER_30_501 VPWR VGND sg13g2_decap_8
XFILLER_42_350 VPWR VGND sg13g2_decap_8
XFILLER_10_291 VPWR VGND sg13g2_decap_8
X_0800_ VPWR _0061_ state\[7\] VGND sg13g2_inv_1
X_0731_ _0292_ VPWR _0139_ VGND net87 _0034_ sg13g2_o21ai_1
X_0662_ _0113_ _0406_ _0407_ net53 _0242_ VPWR VGND sg13g2_a22oi_1
X_0593_ VGND VPWR net28 daisychain\[31\] _0356_ net46 sg13g2_a21oi_1
XFILLER_6_284 VPWR VGND sg13g2_decap_8
XFILLER_37_166 VPWR VGND sg13g2_decap_8
XFILLER_33_394 VPWR VGND sg13g2_decap_8
XFILLER_20_48 VPWR VGND sg13g2_decap_8
X_0929_ net106 VGND VPWR _0089_ daisychain\[25\] clknet_5_28__leaf_clk sg13g2_dfrbpq_1
XFILLER_0_427 VPWR VGND sg13g2_decap_8
XFILLER_29_68 VPWR VGND sg13g2_decap_8
XFILLER_12_501 VPWR VGND sg13g2_decap_8
XFILLER_28_166 VPWR VGND sg13g2_decap_8
XFILLER_43_147 VPWR VGND sg13g2_decap_8
XFILLER_44_637 VPWR VGND sg13g2_decap_8
XFILLER_45_56 VPWR VGND sg13g2_decap_8
XFILLER_24_394 VPWR VGND sg13g2_decap_8
XFILLER_6_39 VPWR VGND sg13g2_decap_8
XFILLER_10_81 VPWR VGND sg13g2_decap_8
XFILLER_3_221 VPWR VGND sg13g2_decap_8
XFILLER_3_298 VPWR VGND sg13g2_decap_8
XFILLER_13_8 VPWR VGND sg13g2_fill_1
XFILLER_19_155 VPWR VGND sg13g2_decap_8
XFILLER_47_420 VPWR VGND sg13g2_decap_8
XFILLER_47_497 VPWR VGND sg13g2_decap_8
XFILLER_15_350 VPWR VGND sg13g2_decap_8
XFILLER_34_147 VPWR VGND sg13g2_decap_8
XFILLER_35_659 VPWR VGND sg13g2_fill_2
XFILLER_43_692 VPWR VGND sg13g2_fill_1
XFILLER_30_375 VPWR VGND sg13g2_decap_8
X_0714_ VGND VPWR net32 daisychain\[61\] _0447_ net33 sg13g2_a21oi_1
X_0645_ VGND VPWR net29 daisychain\[44\] _0395_ net51 sg13g2_a21oi_1
XFILLER_7_560 VPWR VGND sg13g2_decap_8
X_0576_ _0221_ net61 _0342_ _0343_ VPWR VGND sg13g2_a21o_1
XFILLER_25_158 VPWR VGND sg13g2_decap_8
XFILLER_26_637 VPWR VGND sg13g2_decap_8
XFILLER_21_353 VPWR VGND sg13g2_decap_8
XFILLER_31_25 VPWR VGND sg13g2_decap_8
XFILLER_33_191 VPWR VGND sg13g2_decap_8
XFILLER_5_508 VPWR VGND sg13g2_decap_8
XFILLER_0_224 VPWR VGND sg13g2_decap_8
Xoutput14 net14 uio_out[7] VPWR VGND sg13g2_buf_1
XFILLER_29_453 VPWR VGND sg13g2_decap_8
XFILLER_48_217 VPWR VGND sg13g2_decap_8
XFILLER_49_718 VPWR VGND sg13g2_decap_8
XFILLER_16_147 VPWR VGND sg13g2_decap_8
XFILLER_24_191 VPWR VGND sg13g2_decap_8
XFILLER_44_434 VPWR VGND sg13g2_decap_8
XFILLER_12_375 VPWR VGND sg13g2_decap_8
XFILLER_21_80 VPWR VGND sg13g2_decap_8
XFILLER_8_357 VPWR VGND sg13g2_decap_8
XFILLER_39_217 VPWR VGND sg13g2_decap_8
XFILLER_4_585 VPWR VGND sg13g2_decap_8
XFILLER_23_629 VPWR VGND sg13g2_decap_8
XFILLER_35_412 VPWR VGND sg13g2_decap_8
XFILLER_35_489 VPWR VGND sg13g2_decap_8
XFILLER_47_294 VPWR VGND sg13g2_decap_8
XFILLER_48_784 VPWR VGND sg13g2_decap_8
XFILLER_22_139 VPWR VGND sg13g2_decap_8
XFILLER_30_172 VPWR VGND sg13g2_decap_8
X_0628_ _0234_ net73 _0381_ _0382_ VPWR VGND sg13g2_a21o_1
X_0559_ net89 VPWR _0330_ VGND net66 state\[24\] sg13g2_o21ai_1
XFILLER_13_139 VPWR VGND sg13g2_decap_8
XFILLER_26_434 VPWR VGND sg13g2_decap_8
XFILLER_38_294 VPWR VGND sg13g2_decap_8
XFILLER_41_448 VPWR VGND sg13g2_decap_8
XFILLER_42_35 VPWR VGND sg13g2_decap_8
XFILLER_21_150 VPWR VGND sg13g2_decap_8
XFILLER_5_305 VPWR VGND sg13g2_decap_8
XFILLER_1_511 VPWR VGND sg13g2_decap_8
XFILLER_1_588 VPWR VGND sg13g2_decap_8
XFILLER_3_18 VPWR VGND sg13g2_decap_8
XFILLER_49_515 VPWR VGND sg13g2_decap_8
XFILLER_17_423 VPWR VGND sg13g2_decap_8
XFILLER_29_250 VPWR VGND sg13g2_decap_8
XFILLER_44_231 VPWR VGND sg13g2_decap_8
XFILLER_12_172 VPWR VGND sg13g2_decap_8
XFILLER_16_91 VPWR VGND sg13g2_decap_8
XFILLER_32_459 VPWR VGND sg13g2_decap_8
XFILLER_8_154 VPWR VGND sg13g2_decap_8
XFILLER_4_382 VPWR VGND sg13g2_decap_8
XFILLER_27_209 VPWR VGND sg13g2_decap_8
XFILLER_36_710 VPWR VGND sg13g2_fill_2
XFILLER_48_581 VPWR VGND sg13g2_decap_8
XFILLER_23_426 VPWR VGND sg13g2_decap_8
XFILLER_35_286 VPWR VGND sg13g2_decap_8
XFILLER_10_109 VPWR VGND sg13g2_decap_8
XFILLER_2_319 VPWR VGND sg13g2_decap_8
XFILLER_26_231 VPWR VGND sg13g2_decap_8
XFILLER_27_776 VPWR VGND sg13g2_decap_8
XFILLER_37_68 VPWR VGND sg13g2_decap_8
XFILLER_39_592 VPWR VGND sg13g2_decap_8
XFILLER_46_518 VPWR VGND sg13g2_decap_8
XFILLER_14_426 VPWR VGND sg13g2_decap_8
XFILLER_41_245 VPWR VGND sg13g2_decap_8
XFILLER_5_179 VPWR VGND sg13g2_decap_8
XFILLER_5_102 VPWR VGND sg13g2_decap_8
XFILLER_1_385 VPWR VGND sg13g2_decap_8
XFILLER_49_389 VPWR VGND sg13g2_decap_8
XFILLER_49_312 VPWR VGND sg13g2_decap_8
XFILLER_17_220 VPWR VGND sg13g2_decap_8
XFILLER_17_297 VPWR VGND sg13g2_decap_8
XFILLER_18_743 VPWR VGND sg13g2_fill_1
XFILLER_27_90 VPWR VGND sg13g2_decap_8
XFILLER_32_256 VPWR VGND sg13g2_decap_8
XFILLER_45_595 VPWR VGND sg13g2_decap_8
X_0893_ VPWR _0246_ daisychain\[53\] VGND sg13g2_inv_1
X_0962_ net123 VGND VPWR _0122_ daisychain\[58\] clknet_5_8__leaf_clk sg13g2_dfrbpq_1
XFILLER_9_452 VPWR VGND sg13g2_decap_8
XFILLER_23_15 VPWR VGND sg13g2_fill_1
XFILLER_23_223 VPWR VGND sg13g2_decap_8
XFILLER_23_48 VPWR VGND sg13g2_decap_8
XFILLER_36_584 VPWR VGND sg13g2_decap_8
XFILLER_2_116 VPWR VGND sg13g2_decap_8
XFILLER_3_606 VPWR VGND sg13g2_decap_8
XFILLER_46_315 VPWR VGND sg13g2_decap_8
XFILLER_47_805 VPWR VGND sg13g2_decap_8
XFILLER_48_56 VPWR VGND sg13g2_decap_8
XFILLER_14_223 VPWR VGND sg13g2_decap_8
XFILLER_27_573 VPWR VGND sg13g2_decap_8
XFILLER_42_532 VPWR VGND sg13g2_decap_8
XFILLER_10_473 VPWR VGND sg13g2_decap_8
Xfanout93 net99 net93 VPWR VGND sg13g2_buf_1
Xfanout82 net86 net82 VPWR VGND sg13g2_buf_1
Xfanout71 net72 net71 VPWR VGND sg13g2_buf_1
Xfanout60 net63 net60 VPWR VGND sg13g2_buf_1
XFILLER_9_39 VPWR VGND sg13g2_decap_8
XFILLER_2_683 VPWR VGND sg13g2_decap_8
XFILLER_36_7 VPWR VGND sg13g2_fill_2
XFILLER_6_466 VPWR VGND sg13g2_decap_8
XFILLER_18_540 VPWR VGND sg13g2_decap_8
XFILLER_1_182 VPWR VGND sg13g2_decap_8
XFILLER_37_348 VPWR VGND sg13g2_decap_8
XFILLER_49_186 VPWR VGND sg13g2_decap_8
XFILLER_20_237 VPWR VGND sg13g2_decap_8
XFILLER_33_576 VPWR VGND sg13g2_decap_8
XFILLER_45_392 VPWR VGND sg13g2_decap_8
X_0876_ VPWR _0004_ state\[45\] VGND sg13g2_inv_1
X_0945_ net113 VGND VPWR _0105_ daisychain\[41\] clknet_5_2__leaf_clk sg13g2_dfrbpq_1
XFILLER_0_609 VPWR VGND sg13g2_decap_8
XFILLER_18_59 VPWR VGND sg13g2_decap_8
XFILLER_28_348 VPWR VGND sg13g2_decap_8
XFILLER_34_14 VPWR VGND sg13g2_decap_8
XFILLER_43_329 VPWR VGND sg13g2_decap_8
XFILLER_44_819 VPWR VGND sg13g2_decap_4
XFILLER_20_760 VPWR VGND sg13g2_decap_4
XFILLER_24_587 VPWR VGND sg13g2_decap_8
XFILLER_3_403 VPWR VGND sg13g2_decap_8
XFILLER_19_337 VPWR VGND sg13g2_decap_8
XFILLER_46_112 VPWR VGND sg13g2_decap_8
XFILLER_47_602 VPWR VGND sg13g2_decap_8
XFILLER_47_679 VPWR VGND sg13g2_decap_8
XFILLER_15_532 VPWR VGND sg13g2_decap_8
XFILLER_27_370 VPWR VGND sg13g2_decap_8
XFILLER_34_329 VPWR VGND sg13g2_decap_8
XFILLER_46_189 VPWR VGND sg13g2_decap_8
XFILLER_10_270 VPWR VGND sg13g2_decap_8
X_0730_ _0289_ VPWR _0138_ VGND net87 _0033_ sg13g2_o21ai_1
X_0661_ VGND VPWR net30 daisychain\[48\] _0407_ net53 sg13g2_a21oi_1
XFILLER_6_263 VPWR VGND sg13g2_decap_8
XFILLER_2_480 VPWR VGND sg13g2_decap_8
X_0592_ _0225_ net69 _0354_ _0355_ VPWR VGND sg13g2_a21o_1
XFILLER_18_381 VPWR VGND sg13g2_decap_8
XFILLER_1_84 VPWR VGND sg13g2_decap_8
XFILLER_26_808 VPWR VGND sg13g2_decap_8
XFILLER_37_145 VPWR VGND sg13g2_decap_8
XFILLER_21_535 VPWR VGND sg13g2_decap_8
XFILLER_33_373 VPWR VGND sg13g2_decap_8
XFILLER_0_406 VPWR VGND sg13g2_decap_8
XFILLER_20_27 VPWR VGND sg13g2_decap_8
X_0859_ VPWR _0229_ daisychain\[36\] VGND sg13g2_inv_1
X_0928_ net105 VGND VPWR _0088_ daisychain\[24\] clknet_5_23__leaf_clk sg13g2_dfrbpq_1
XFILLER_28_145 VPWR VGND sg13g2_decap_8
XFILLER_29_47 VPWR VGND sg13g2_decap_8
XFILLER_16_329 VPWR VGND sg13g2_decap_8
XFILLER_24_373 VPWR VGND sg13g2_decap_8
XFILLER_43_126 VPWR VGND sg13g2_decap_8
XFILLER_44_616 VPWR VGND sg13g2_decap_8
XFILLER_45_35 VPWR VGND sg13g2_decap_8
XFILLER_12_557 VPWR VGND sg13g2_decap_8
XFILLER_3_200 VPWR VGND sg13g2_decap_8
XFILLER_8_539 VPWR VGND sg13g2_decap_8
XFILLER_6_18 VPWR VGND sg13g2_decap_8
XFILLER_10_60 VPWR VGND sg13g2_decap_8
XFILLER_3_277 VPWR VGND sg13g2_decap_8
XFILLER_19_134 VPWR VGND sg13g2_decap_8
XFILLER_34_126 VPWR VGND sg13g2_decap_8
XFILLER_47_476 VPWR VGND sg13g2_decap_8
XFILLER_30_354 VPWR VGND sg13g2_decap_8
XFILLER_31_822 VPWR VGND sg13g2_fill_1
XFILLER_35_90 VPWR VGND sg13g2_decap_8
X_0713_ VGND VPWR _0446_ _0445_ _0444_ sg13g2_or2_1
X_0644_ _0238_ net74 _0393_ _0394_ VPWR VGND sg13g2_a21o_1
XFILLER_38_465 VPWR VGND sg13g2_decap_8
X_0575_ net84 VPWR _0342_ VGND net61 state\[28\] sg13g2_o21ai_1
XFILLER_15_49 VPWR VGND sg13g2_decap_8
XFILLER_22_822 VPWR VGND sg13g2_fill_1
XFILLER_25_137 VPWR VGND sg13g2_decap_8
XFILLER_26_616 VPWR VGND sg13g2_decap_8
XFILLER_33_170 VPWR VGND sg13g2_decap_8
XFILLER_21_332 VPWR VGND sg13g2_decap_8
XFILLER_0_203 VPWR VGND sg13g2_decap_8
Xoutput15 net15 uo_out[0] VPWR VGND sg13g2_buf_1
XFILLER_16_126 VPWR VGND sg13g2_decap_8
XFILLER_17_638 VPWR VGND sg13g2_decap_8
XFILLER_29_432 VPWR VGND sg13g2_decap_8
XFILLER_44_413 VPWR VGND sg13g2_decap_8
XFILLER_12_354 VPWR VGND sg13g2_decap_8
XFILLER_24_170 VPWR VGND sg13g2_decap_8
XFILLER_8_336 VPWR VGND sg13g2_decap_8
XFILLER_4_564 VPWR VGND sg13g2_decap_8
XFILLER_48_763 VPWR VGND sg13g2_decap_8
XFILLER_22_118 VPWR VGND sg13g2_decap_8
XFILLER_23_608 VPWR VGND sg13g2_decap_8
XFILLER_35_468 VPWR VGND sg13g2_decap_8
XFILLER_47_273 VPWR VGND sg13g2_decap_8
XFILLER_30_151 VPWR VGND sg13g2_decap_8
XFILLER_43_490 VPWR VGND sg13g2_decap_8
X_0627_ net95 VPWR _0381_ VGND net73 state\[41\] sg13g2_o21ai_1
X_0558_ _0087_ _0328_ _0329_ net43 _0216_ VPWR VGND sg13g2_a22oi_1
XFILLER_26_413 VPWR VGND sg13g2_decap_8
XFILLER_38_273 VPWR VGND sg13g2_decap_8
X_0489_ VGND VPWR net23 daisychain\[5\] _0278_ net39 sg13g2_a21oi_1
XFILLER_13_118 VPWR VGND sg13g2_decap_8
XFILLER_14_608 VPWR VGND sg13g2_decap_4
XFILLER_34_490 VPWR VGND sg13g2_decap_8
XFILLER_41_427 VPWR VGND sg13g2_decap_8
XFILLER_42_14 VPWR VGND sg13g2_decap_8
XFILLER_1_567 VPWR VGND sg13g2_decap_8
XFILLER_16_70 VPWR VGND sg13g2_decap_8
XFILLER_17_402 VPWR VGND sg13g2_decap_8
XFILLER_17_479 VPWR VGND sg13g2_decap_8
XFILLER_32_438 VPWR VGND sg13g2_decap_8
XFILLER_44_210 VPWR VGND sg13g2_decap_8
XFILLER_44_287 VPWR VGND sg13g2_decap_8
XFILLER_12_151 VPWR VGND sg13g2_decap_8
XFILLER_13_630 VPWR VGND sg13g2_decap_8
XFILLER_9_634 VPWR VGND sg13g2_decap_8
XFILLER_9_601 VPWR VGND sg13g2_decap_8
XFILLER_8_133 VPWR VGND sg13g2_decap_8
XFILLER_4_361 VPWR VGND sg13g2_decap_8
XFILLER_48_560 VPWR VGND sg13g2_decap_8
XFILLER_16_490 VPWR VGND sg13g2_decap_8
XFILLER_23_405 VPWR VGND sg13g2_decap_8
XFILLER_35_265 VPWR VGND sg13g2_decap_8
XFILLER_12_39 VPWR VGND sg13g2_decap_8
XFILLER_37_14 VPWR VGND sg13g2_decap_4
XFILLER_14_405 VPWR VGND sg13g2_decap_8
XFILLER_26_210 VPWR VGND sg13g2_decap_8
XFILLER_26_287 VPWR VGND sg13g2_decap_8
XFILLER_27_722 VPWR VGND sg13g2_decap_8
XFILLER_27_788 VPWR VGND sg13g2_fill_2
XFILLER_37_47 VPWR VGND sg13g2_decap_8
XFILLER_41_224 VPWR VGND sg13g2_decap_8
XFILLER_10_666 VPWR VGND sg13g2_fill_1
XFILLER_22_482 VPWR VGND sg13g2_decap_8
XFILLER_5_158 VPWR VGND sg13g2_decap_8
XFILLER_1_364 VPWR VGND sg13g2_decap_8
XFILLER_49_368 VPWR VGND sg13g2_decap_8
XFILLER_17_276 VPWR VGND sg13g2_decap_8
XFILLER_20_419 VPWR VGND sg13g2_decap_8
XFILLER_32_235 VPWR VGND sg13g2_decap_8
XFILLER_45_574 VPWR VGND sg13g2_decap_8
X_0961_ net123 VGND VPWR _0121_ daisychain\[57\] clknet_5_8__leaf_clk sg13g2_dfrbpq_1
XFILLER_13_482 VPWR VGND sg13g2_decap_8
X_0892_ VPWR _0013_ state\[53\] VGND sg13g2_inv_1
XFILLER_9_431 VPWR VGND sg13g2_decap_8
XFILLER_4_95 VPWR VGND sg13g2_decap_8
XFILLER_23_202 VPWR VGND sg13g2_decap_8
XFILLER_36_563 VPWR VGND sg13g2_decap_8
XFILLER_23_279 VPWR VGND sg13g2_decap_8
Xclkbuf_5_18__f_clk clknet_5_18__leaf_clk clknet_4_9_0_clk VPWR VGND sg13g2_buf_16
XFILLER_19_519 VPWR VGND sg13g2_decap_8
XFILLER_48_35 VPWR VGND sg13g2_decap_8
XFILLER_14_202 VPWR VGND sg13g2_decap_8
XFILLER_14_279 VPWR VGND sg13g2_decap_8
XFILLER_15_714 VPWR VGND sg13g2_fill_2
XFILLER_27_552 VPWR VGND sg13g2_decap_8
XFILLER_30_739 VPWR VGND sg13g2_fill_2
XFILLER_42_511 VPWR VGND sg13g2_decap_8
XFILLER_42_588 VPWR VGND sg13g2_decap_8
XFILLER_9_18 VPWR VGND sg13g2_decap_8
XFILLER_10_452 VPWR VGND sg13g2_decap_8
XFILLER_23_780 VPWR VGND sg13g2_fill_1
Xfanout94 net99 net94 VPWR VGND sg13g2_buf_1
Xfanout83 net86 net83 VPWR VGND sg13g2_buf_1
Xfanout72 net78 net72 VPWR VGND sg13g2_buf_1
Xfanout61 net63 net61 VPWR VGND sg13g2_buf_1
Xfanout50 net51 net50 VPWR VGND sg13g2_buf_1
XFILLER_6_445 VPWR VGND sg13g2_decap_8
XFILLER_1_161 VPWR VGND sg13g2_decap_8
XFILLER_2_662 VPWR VGND sg13g2_decap_8
XFILLER_37_327 VPWR VGND sg13g2_decap_8
XFILLER_45_371 VPWR VGND sg13g2_decap_8
XFILLER_49_165 VPWR VGND sg13g2_decap_8
XFILLER_20_216 VPWR VGND sg13g2_decap_8
XFILLER_33_555 VPWR VGND sg13g2_decap_8
X_0944_ net113 VGND VPWR _0104_ daisychain\[40\] clknet_5_2__leaf_clk sg13g2_dfrbpq_1
X_0875_ VPWR _0237_ daisychain\[44\] VGND sg13g2_inv_1
XFILLER_18_38 VPWR VGND sg13g2_decap_8
XFILLER_28_327 VPWR VGND sg13g2_decap_8
XFILLER_24_566 VPWR VGND sg13g2_decap_8
XFILLER_43_308 VPWR VGND sg13g2_decap_8
XFILLER_11_249 VPWR VGND sg13g2_decap_8
XFILLER_3_459 VPWR VGND sg13g2_decap_8
XFILLER_15_511 VPWR VGND sg13g2_decap_8
XFILLER_19_316 VPWR VGND sg13g2_decap_8
XFILLER_34_308 VPWR VGND sg13g2_decap_8
XFILLER_46_168 VPWR VGND sg13g2_decap_8
XFILLER_47_658 VPWR VGND sg13g2_decap_8
XFILLER_15_588 VPWR VGND sg13g2_fill_2
XFILLER_30_536 VPWR VGND sg13g2_decap_8
XFILLER_30_569 VPWR VGND sg13g2_decap_8
XFILLER_42_385 VPWR VGND sg13g2_decap_8
XFILLER_40_91 VPWR VGND sg13g2_decap_8
X_0660_ _0242_ net76 _0405_ _0406_ VPWR VGND sg13g2_a21o_1
X_0591_ net94 VPWR _0354_ VGND net69 state\[32\] sg13g2_o21ai_1
XFILLER_7_798 VPWR VGND sg13g2_fill_1
XFILLER_6_242 VPWR VGND sg13g2_decap_8
XFILLER_27_4 VPWR VGND sg13g2_decap_4
XFILLER_37_124 VPWR VGND sg13g2_decap_8
XFILLER_18_360 VPWR VGND sg13g2_decap_8
XFILLER_1_63 VPWR VGND sg13g2_decap_8
XFILLER_25_319 VPWR VGND sg13g2_decap_8
XFILLER_33_352 VPWR VGND sg13g2_decap_8
XFILLER_21_514 VPWR VGND sg13g2_decap_8
XFILLER_21_569 VPWR VGND sg13g2_decap_8
X_0927_ net105 VGND VPWR _0087_ daisychain\[23\] clknet_5_29__leaf_clk sg13g2_dfrbpq_1
X_0858_ VPWR _0026_ state\[36\] VGND sg13g2_inv_1
X_0789_ VPWR _0194_ daisychain\[1\] VGND sg13g2_inv_1
XFILLER_16_308 VPWR VGND sg13g2_decap_8
XFILLER_28_124 VPWR VGND sg13g2_decap_8
XFILLER_29_614 VPWR VGND sg13g2_decap_8
XFILLER_43_105 VPWR VGND sg13g2_decap_8
XFILLER_45_14 VPWR VGND sg13g2_decap_8
XFILLER_12_536 VPWR VGND sg13g2_decap_8
XFILLER_24_352 VPWR VGND sg13g2_decap_8
XFILLER_36_190 VPWR VGND sg13g2_decap_8
XFILLER_8_518 VPWR VGND sg13g2_decap_8
XFILLER_19_113 VPWR VGND sg13g2_decap_8
XFILLER_3_256 VPWR VGND sg13g2_decap_8
XFILLER_19_92 VPWR VGND sg13g2_decap_8
XFILLER_34_105 VPWR VGND sg13g2_decap_8
XFILLER_47_455 VPWR VGND sg13g2_decap_8
XFILLER_15_385 VPWR VGND sg13g2_decap_8
XFILLER_30_333 VPWR VGND sg13g2_decap_8
XFILLER_42_182 VPWR VGND sg13g2_decap_8
XFILLER_3_790 VPWR VGND sg13g2_fill_2
X_0712_ net80 VPWR _0445_ VGND net56 state\[62\] sg13g2_o21ai_1
X_0643_ net96 VPWR _0393_ VGND net74 state\[45\] sg13g2_o21ai_1
X_0574_ _0091_ _0340_ _0341_ net37 _0220_ VPWR VGND sg13g2_a22oi_1
XFILLER_7_595 VPWR VGND sg13g2_decap_8
XFILLER_38_444 VPWR VGND sg13g2_decap_8
XFILLER_15_28 VPWR VGND sg13g2_decap_8
XFILLER_21_311 VPWR VGND sg13g2_decap_8
XFILLER_25_116 VPWR VGND sg13g2_decap_8
XFILLER_40_119 VPWR VGND sg13g2_decap_8
XFILLER_41_609 VPWR VGND sg13g2_decap_8
XFILLER_21_388 VPWR VGND sg13g2_decap_8
XFILLER_0_259 VPWR VGND sg13g2_decap_8
XFILLER_29_411 VPWR VGND sg13g2_decap_8
Xoutput16 net16 uo_out[1] VPWR VGND sg13g2_buf_1
XFILLER_16_105 VPWR VGND sg13g2_decap_8
XFILLER_29_488 VPWR VGND sg13g2_decap_8
XFILLER_44_469 VPWR VGND sg13g2_decap_8
XFILLER_12_333 VPWR VGND sg13g2_decap_8
XFILLER_8_315 VPWR VGND sg13g2_decap_8
XFILLER_4_543 VPWR VGND sg13g2_decap_8
XFILLER_0_782 VPWR VGND sg13g2_fill_2
XFILLER_47_252 VPWR VGND sg13g2_decap_8
XFILLER_48_742 VPWR VGND sg13g2_decap_8
XFILLER_15_182 VPWR VGND sg13g2_decap_8
XFILLER_30_130 VPWR VGND sg13g2_decap_8
XFILLER_35_447 VPWR VGND sg13g2_decap_8
Xclkbuf_0_clk clknet_0_clk clk VPWR VGND sg13g2_buf_16
XFILLER_7_84 VPWR VGND sg13g2_decap_8
XFILLER_7_392 VPWR VGND sg13g2_decap_8
X_0626_ _0104_ _0379_ _0380_ net52 _0233_ VPWR VGND sg13g2_a22oi_1
X_0557_ VGND VPWR net26 daisychain\[22\] _0329_ net37 sg13g2_a21oi_1
XFILLER_26_469 VPWR VGND sg13g2_decap_8
XFILLER_26_49 VPWR VGND sg13g2_decap_8
XFILLER_38_252 VPWR VGND sg13g2_decap_8
XFILLER_39_742 VPWR VGND sg13g2_fill_2
XFILLER_41_406 VPWR VGND sg13g2_decap_8
X_0488_ _0199_ net60 _0276_ _0277_ VPWR VGND sg13g2_a21o_1
XFILLER_21_185 VPWR VGND sg13g2_decap_8
XFILLER_6_819 VPWR VGND sg13g2_decap_4
XFILLER_1_546 VPWR VGND sg13g2_decap_8
XFILLER_17_458 VPWR VGND sg13g2_decap_8
XFILLER_25_480 VPWR VGND sg13g2_decap_8
XFILLER_29_285 VPWR VGND sg13g2_decap_8
XFILLER_32_417 VPWR VGND sg13g2_decap_8
XFILLER_44_266 VPWR VGND sg13g2_decap_8
XFILLER_45_778 VPWR VGND sg13g2_decap_8
XFILLER_12_130 VPWR VGND sg13g2_decap_8
XFILLER_32_81 VPWR VGND sg13g2_decap_8
XFILLER_40_483 VPWR VGND sg13g2_fill_2
XFILLER_8_189 VPWR VGND sg13g2_decap_8
XFILLER_8_112 VPWR VGND sg13g2_decap_8
XFILLER_4_340 VPWR VGND sg13g2_decap_8
XFILLER_35_244 VPWR VGND sg13g2_decap_8
XFILLER_36_701 VPWR VGND sg13g2_decap_4
XFILLER_36_712 VPWR VGND sg13g2_fill_1
XFILLER_12_18 VPWR VGND sg13g2_decap_8
XFILLER_31_494 VPWR VGND sg13g2_decap_8
XFILLER_27_701 VPWR VGND sg13g2_fill_1
X_0609_ VGND VPWR net28 daisychain\[35\] _0368_ net46 sg13g2_a21oi_1
XFILLER_26_266 VPWR VGND sg13g2_decap_8
XFILLER_41_203 VPWR VGND sg13g2_decap_8
XFILLER_42_715 VPWR VGND sg13g2_decap_4
XFILLER_10_612 VPWR VGND sg13g2_decap_4
XFILLER_22_461 VPWR VGND sg13g2_decap_8
XFILLER_5_137 VPWR VGND sg13g2_decap_8
XFILLER_1_343 VPWR VGND sg13g2_decap_8
XFILLER_17_255 VPWR VGND sg13g2_decap_8
XFILLER_45_553 VPWR VGND sg13g2_decap_8
XFILLER_49_347 VPWR VGND sg13g2_decap_8
XFILLER_13_461 VPWR VGND sg13g2_decap_8
XFILLER_32_214 VPWR VGND sg13g2_decap_8
XFILLER_40_280 VPWR VGND sg13g2_decap_8
XFILLER_43_91 VPWR VGND sg13g2_decap_8
X_0960_ net101 VGND VPWR _0120_ daisychain\[56\] clknet_5_9__leaf_clk sg13g2_dfrbpq_1
XFILLER_9_410 VPWR VGND sg13g2_decap_8
X_0891_ VPWR _0245_ daisychain\[52\] VGND sg13g2_inv_1
XFILLER_9_487 VPWR VGND sg13g2_decap_8
XFILLER_28_509 VPWR VGND sg13g2_decap_8
XFILLER_4_74 VPWR VGND sg13g2_decap_8
XFILLER_36_542 VPWR VGND sg13g2_decap_8
XFILLER_23_258 VPWR VGND sg13g2_decap_8
XFILLER_31_291 VPWR VGND sg13g2_decap_8
XFILLER_48_14 VPWR VGND sg13g2_decap_8
XFILLER_27_531 VPWR VGND sg13g2_decap_8
XFILLER_14_258 VPWR VGND sg13g2_decap_8
XFILLER_15_704 VPWR VGND sg13g2_fill_1
XFILLER_42_567 VPWR VGND sg13g2_decap_8
Xfanout73 net77 net73 VPWR VGND sg13g2_buf_1
Xfanout62 net63 net62 VPWR VGND sg13g2_buf_1
Xfanout51 net54 net51 VPWR VGND sg13g2_buf_1
Xfanout40 net42 net40 VPWR VGND sg13g2_buf_1
XFILLER_10_431 VPWR VGND sg13g2_decap_8
XFILLER_13_83 VPWR VGND sg13g2_decap_8
Xfanout95 net99 net95 VPWR VGND sg13g2_buf_1
Xfanout84 net86 net84 VPWR VGND sg13g2_buf_1
XFILLER_6_424 VPWR VGND sg13g2_decap_8
XFILLER_1_140 VPWR VGND sg13g2_decap_8
XFILLER_29_8 VPWR VGND sg13g2_fill_1
XFILLER_2_641 VPWR VGND sg13g2_decap_8
XFILLER_37_306 VPWR VGND sg13g2_decap_8
XFILLER_49_144 VPWR VGND sg13g2_decap_8
XFILLER_33_534 VPWR VGND sg13g2_decap_8
XFILLER_38_91 VPWR VGND sg13g2_decap_8
XFILLER_45_350 VPWR VGND sg13g2_decap_8
Xclkbuf_5_24__f_clk clknet_5_24__leaf_clk clknet_4_12_0_clk VPWR VGND sg13g2_buf_16
X_0874_ VPWR _0003_ state\[44\] VGND sg13g2_inv_1
X_0943_ net115 VGND VPWR _0103_ daisychain\[39\] clknet_5_11__leaf_clk sg13g2_dfrbpq_1
XFILLER_9_284 VPWR VGND sg13g2_decap_8
XFILLER_48_0 VPWR VGND sg13g2_decap_8
XFILLER_28_306 VPWR VGND sg13g2_decap_8
XFILLER_11_228 VPWR VGND sg13g2_decap_8
XFILLER_24_545 VPWR VGND sg13g2_decap_8
XFILLER_34_49 VPWR VGND sg13g2_decap_8
XFILLER_36_372 VPWR VGND sg13g2_decap_4
XFILLER_3_438 VPWR VGND sg13g2_decap_8
XFILLER_46_147 VPWR VGND sg13g2_decap_8
XFILLER_47_637 VPWR VGND sg13g2_decap_8
XFILLER_15_567 VPWR VGND sg13g2_decap_8
XFILLER_24_93 VPWR VGND sg13g2_decap_8
XFILLER_30_515 VPWR VGND sg13g2_decap_8
XFILLER_42_364 VPWR VGND sg13g2_decap_8
XFILLER_40_70 VPWR VGND sg13g2_decap_8
XFILLER_41_7 VPWR VGND sg13g2_decap_8
X_0590_ _0095_ _0352_ _0353_ net46 _0224_ VPWR VGND sg13g2_a22oi_1
XFILLER_6_298 VPWR VGND sg13g2_decap_8
XFILLER_6_221 VPWR VGND sg13g2_decap_8
XFILLER_1_42 VPWR VGND sg13g2_decap_8
XFILLER_37_103 VPWR VGND sg13g2_decap_8
XFILLER_38_626 VPWR VGND sg13g2_decap_4
XFILLER_33_331 VPWR VGND sg13g2_decap_8
XFILLER_21_548 VPWR VGND sg13g2_decap_8
X_0857_ VPWR _0228_ daisychain\[35\] VGND sg13g2_inv_1
X_0926_ net105 VGND VPWR _0086_ daisychain\[22\] clknet_5_29__leaf_clk sg13g2_dfrbpq_1
X_0788_ VPWR _0043_ state\[1\] VGND sg13g2_inv_1
XFILLER_25_821 VPWR VGND sg13g2_fill_2
XFILLER_28_103 VPWR VGND sg13g2_decap_8
XFILLER_12_515 VPWR VGND sg13g2_decap_8
XFILLER_24_331 VPWR VGND sg13g2_decap_8
XFILLER_3_235 VPWR VGND sg13g2_decap_8
XFILLER_10_95 VPWR VGND sg13g2_decap_8
XFILLER_19_71 VPWR VGND sg13g2_decap_8
XFILLER_47_434 VPWR VGND sg13g2_decap_8
XFILLER_15_364 VPWR VGND sg13g2_decap_8
XFILLER_19_169 VPWR VGND sg13g2_decap_8
XFILLER_30_312 VPWR VGND sg13g2_decap_8
XFILLER_31_813 VPWR VGND sg13g2_decap_8
XFILLER_42_161 VPWR VGND sg13g2_decap_8
XFILLER_43_651 VPWR VGND sg13g2_decap_8
XFILLER_11_592 VPWR VGND sg13g2_decap_8
XFILLER_30_389 VPWR VGND sg13g2_decap_8
X_0711_ daisychain\[62\] net56 _0444_ VPWR VGND sg13g2_nor2b_1
XFILLER_7_574 VPWR VGND sg13g2_decap_8
X_0642_ _0108_ _0391_ _0392_ net50 _0237_ VPWR VGND sg13g2_a22oi_1
X_0573_ VGND VPWR net24 daisychain\[26\] _0341_ net37 sg13g2_a21oi_1
XFILLER_38_423 VPWR VGND sg13g2_decap_8
XFILLER_21_367 VPWR VGND sg13g2_decap_8
XFILLER_31_39 VPWR VGND sg13g2_decap_8
X_0909_ net103 VGND VPWR _0069_ daisychain\[5\] clknet_5_22__leaf_clk sg13g2_dfrbpq_1
Xoutput17 net17 uo_out[2] VPWR VGND sg13g2_buf_1
XFILLER_0_238 VPWR VGND sg13g2_decap_8
XFILLER_12_312 VPWR VGND sg13g2_decap_8
XFILLER_25_662 VPWR VGND sg13g2_fill_2
XFILLER_29_467 VPWR VGND sg13g2_decap_8
XFILLER_31_109 VPWR VGND sg13g2_decap_8
XFILLER_44_448 VPWR VGND sg13g2_decap_8
XFILLER_12_389 VPWR VGND sg13g2_decap_8
XFILLER_21_94 VPWR VGND sg13g2_decap_8
XFILLER_4_599 VPWR VGND sg13g2_decap_8
XFILLER_4_522 VPWR VGND sg13g2_decap_8
XFILLER_0_772 VPWR VGND sg13g2_fill_2
XFILLER_35_426 VPWR VGND sg13g2_decap_8
XFILLER_47_231 VPWR VGND sg13g2_decap_8
XFILLER_48_798 VPWR VGND sg13g2_decap_8
XFILLER_48_721 VPWR VGND sg13g2_decap_8
XFILLER_15_161 VPWR VGND sg13g2_decap_8
XFILLER_31_654 VPWR VGND sg13g2_decap_4
XFILLER_46_91 VPWR VGND sg13g2_decap_8
XFILLER_30_186 VPWR VGND sg13g2_decap_8
X_0625_ VGND VPWR net30 daisychain\[39\] _0380_ net52 sg13g2_a21oi_1
XFILLER_7_63 VPWR VGND sg13g2_decap_8
XFILLER_7_371 VPWR VGND sg13g2_decap_8
X_0556_ _0216_ net66 _0327_ _0328_ VPWR VGND sg13g2_a21o_1
X_0487_ net87 VPWR _0276_ VGND net64 state\[6\] sg13g2_o21ai_1
XFILLER_26_28 VPWR VGND sg13g2_decap_8
XFILLER_26_448 VPWR VGND sg13g2_decap_8
XFILLER_38_231 VPWR VGND sg13g2_decap_8
XFILLER_21_164 VPWR VGND sg13g2_decap_8
XFILLER_22_643 VPWR VGND sg13g2_decap_8
XFILLER_22_698 VPWR VGND sg13g2_decap_4
XFILLER_42_49 VPWR VGND sg13g2_decap_8
XFILLER_5_319 VPWR VGND sg13g2_decap_8
XFILLER_1_525 VPWR VGND sg13g2_decap_8
XFILLER_17_437 VPWR VGND sg13g2_decap_8
XFILLER_29_264 VPWR VGND sg13g2_decap_8
Xclkbuf_5_5__f_clk clknet_5_5__leaf_clk clknet_4_2_0_clk VPWR VGND sg13g2_buf_16
XFILLER_49_529 VPWR VGND sg13g2_decap_8
XFILLER_13_621 VPWR VGND sg13g2_decap_4
XFILLER_40_462 VPWR VGND sg13g2_decap_8
XFILLER_44_245 VPWR VGND sg13g2_decap_8
XFILLER_12_186 VPWR VGND sg13g2_decap_8
XFILLER_32_60 VPWR VGND sg13g2_decap_8
XFILLER_8_168 VPWR VGND sg13g2_decap_8
XFILLER_4_396 VPWR VGND sg13g2_decap_8
XFILLER_35_223 VPWR VGND sg13g2_decap_8
XFILLER_48_595 VPWR VGND sg13g2_decap_8
XFILLER_31_473 VPWR VGND sg13g2_decap_8
X_0608_ _0229_ net70 _0366_ _0367_ VPWR VGND sg13g2_a21o_1
X_0539_ net96 VPWR _0315_ VGND net74 state\[19\] sg13g2_o21ai_1
XFILLER_22_440 VPWR VGND sg13g2_decap_8
XFILLER_26_245 VPWR VGND sg13g2_decap_8
XFILLER_41_259 VPWR VGND sg13g2_decap_8
XFILLER_6_606 VPWR VGND sg13g2_decap_8
XFILLER_5_116 VPWR VGND sg13g2_decap_8
XFILLER_1_322 VPWR VGND sg13g2_decap_8
XFILLER_1_399 VPWR VGND sg13g2_decap_8
XFILLER_49_326 VPWR VGND sg13g2_decap_8
XFILLER_17_234 VPWR VGND sg13g2_decap_8
XFILLER_18_713 VPWR VGND sg13g2_fill_2
XFILLER_45_532 VPWR VGND sg13g2_decap_8
XFILLER_13_440 VPWR VGND sg13g2_decap_8
XFILLER_43_70 VPWR VGND sg13g2_decap_8
X_0890_ VPWR _0012_ state\[52\] VGND sg13g2_inv_1
XFILLER_9_466 VPWR VGND sg13g2_decap_8
XFILLER_5_661 VPWR VGND sg13g2_decap_8
XFILLER_4_193 VPWR VGND sg13g2_decap_8
XFILLER_36_521 VPWR VGND sg13g2_decap_8
XFILLER_4_53 VPWR VGND sg13g2_decap_8
XFILLER_23_237 VPWR VGND sg13g2_decap_8
XFILLER_36_598 VPWR VGND sg13g2_decap_8
XFILLER_48_392 VPWR VGND sg13g2_decap_8
XFILLER_31_270 VPWR VGND sg13g2_decap_8
XFILLER_27_510 VPWR VGND sg13g2_decap_8
XFILLER_27_587 VPWR VGND sg13g2_decap_8
XFILLER_39_392 VPWR VGND sg13g2_decap_8
XFILLER_46_329 VPWR VGND sg13g2_decap_8
XFILLER_47_819 VPWR VGND sg13g2_decap_4
XFILLER_10_410 VPWR VGND sg13g2_decap_8
XFILLER_14_237 VPWR VGND sg13g2_decap_8
XFILLER_42_546 VPWR VGND sg13g2_decap_8
Xfanout30 net31 net30 VPWR VGND sg13g2_buf_1
Xfanout96 net99 net96 VPWR VGND sg13g2_buf_1
Xfanout85 net86 net85 VPWR VGND sg13g2_buf_1
Xfanout74 net77 net74 VPWR VGND sg13g2_buf_1
Xfanout63 net78 net63 VPWR VGND sg13g2_buf_1
Xfanout52 net53 net52 VPWR VGND sg13g2_buf_1
Xfanout41 net42 net41 VPWR VGND sg13g2_buf_1
XFILLER_10_487 VPWR VGND sg13g2_decap_8
XFILLER_13_62 VPWR VGND sg13g2_decap_8
XFILLER_2_620 VPWR VGND sg13g2_decap_8
XFILLER_6_403 VPWR VGND sg13g2_decap_8
XFILLER_1_196 VPWR VGND sg13g2_decap_8
XFILLER_2_697 VPWR VGND sg13g2_fill_2
XFILLER_38_70 VPWR VGND sg13g2_decap_8
XFILLER_49_123 VPWR VGND sg13g2_decap_8
XFILLER_18_554 VPWR VGND sg13g2_decap_8
XFILLER_18_587 VPWR VGND sg13g2_decap_8
XFILLER_33_513 VPWR VGND sg13g2_decap_8
X_0873_ VPWR _0236_ daisychain\[43\] VGND sg13g2_inv_1
X_0942_ net115 VGND VPWR _0102_ daisychain\[38\] clknet_5_11__leaf_clk sg13g2_dfrbpq_1
XFILLER_9_263 VPWR VGND sg13g2_decap_8
XFILLER_5_480 VPWR VGND sg13g2_decap_8
XFILLER_36_351 VPWR VGND sg13g2_decap_8
XFILLER_49_690 VPWR VGND sg13g2_decap_8
XFILLER_11_207 VPWR VGND sg13g2_decap_8
XFILLER_34_28 VPWR VGND sg13g2_decap_8
XFILLER_36_395 VPWR VGND sg13g2_decap_8
XFILLER_3_417 VPWR VGND sg13g2_decap_8
Xclkbuf_5_30__f_clk clknet_5_30__leaf_clk clknet_4_15_0_clk VPWR VGND sg13g2_buf_16
XFILLER_1_7 VPWR VGND sg13g2_decap_8
XFILLER_47_616 VPWR VGND sg13g2_decap_8
XFILLER_15_546 VPWR VGND sg13g2_decap_8
XFILLER_27_384 VPWR VGND sg13g2_decap_8
XFILLER_42_343 VPWR VGND sg13g2_decap_8
XFILLER_46_126 VPWR VGND sg13g2_decap_8
XFILLER_10_284 VPWR VGND sg13g2_decap_8
XFILLER_24_72 VPWR VGND sg13g2_decap_8
XFILLER_7_712 VPWR VGND sg13g2_decap_8
XFILLER_7_701 VPWR VGND sg13g2_decap_8
XFILLER_6_200 VPWR VGND sg13g2_decap_8
XFILLER_34_7 VPWR VGND sg13g2_decap_8
XFILLER_7_778 VPWR VGND sg13g2_fill_2
XFILLER_6_277 VPWR VGND sg13g2_decap_8
XFILLER_1_21 VPWR VGND sg13g2_decap_8
XFILLER_1_98 VPWR VGND sg13g2_decap_8
XFILLER_2_494 VPWR VGND sg13g2_decap_8
XFILLER_37_159 VPWR VGND sg13g2_decap_8
XFILLER_18_395 VPWR VGND sg13g2_decap_8
XFILLER_33_310 VPWR VGND sg13g2_decap_8
XFILLER_33_387 VPWR VGND sg13g2_decap_8
XFILLER_46_693 VPWR VGND sg13g2_decap_8
X_0856_ VPWR _0025_ state\[35\] VGND sg13g2_inv_1
X_0925_ net105 VGND VPWR _0085_ daisychain\[21\] clknet_5_29__leaf_clk sg13g2_dfrbpq_1
X_0787_ VPWR _0193_ daisychain\[0\] VGND sg13g2_inv_1
XFILLER_24_310 VPWR VGND sg13g2_decap_8
XFILLER_25_800 VPWR VGND sg13g2_decap_8
XFILLER_28_159 VPWR VGND sg13g2_decap_8
XFILLER_45_49 VPWR VGND sg13g2_decap_8
XFILLER_20_582 VPWR VGND sg13g2_decap_8
XFILLER_24_387 VPWR VGND sg13g2_decap_8
XFILLER_10_74 VPWR VGND sg13g2_decap_8
XFILLER_3_214 VPWR VGND sg13g2_decap_8
XFILLER_19_148 VPWR VGND sg13g2_decap_8
XFILLER_19_50 VPWR VGND sg13g2_decap_8
XFILLER_47_413 VPWR VGND sg13g2_decap_8
XFILLER_15_343 VPWR VGND sg13g2_decap_8
XFILLER_27_181 VPWR VGND sg13g2_decap_8
XFILLER_42_140 VPWR VGND sg13g2_decap_8
XFILLER_43_630 VPWR VGND sg13g2_decap_8
XFILLER_11_571 VPWR VGND sg13g2_decap_8
XFILLER_30_368 VPWR VGND sg13g2_decap_8
X_0710_ _0125_ _0442_ _0443_ net33 _0254_ VPWR VGND sg13g2_a22oi_1
X_0641_ VGND VPWR net29 daisychain\[43\] _0392_ net50 sg13g2_a21oi_1
XFILLER_7_553 VPWR VGND sg13g2_decap_8
XFILLER_2_291 VPWR VGND sg13g2_decap_8
XFILLER_32_4 VPWR VGND sg13g2_decap_8
XFILLER_38_402 VPWR VGND sg13g2_decap_8
X_0572_ _0220_ net61 _0339_ _0340_ VPWR VGND sg13g2_a21o_1
XFILLER_15_19 VPWR VGND sg13g2_fill_1
XFILLER_18_192 VPWR VGND sg13g2_decap_8
XFILLER_38_479 VPWR VGND sg13g2_decap_4
XFILLER_46_490 VPWR VGND sg13g2_decap_8
X_1055_ daisychain\[63\] net22 VPWR VGND sg13g2_buf_1
XFILLER_21_346 VPWR VGND sg13g2_decap_8
XFILLER_31_18 VPWR VGND sg13g2_decap_8
XFILLER_33_184 VPWR VGND sg13g2_decap_8
XFILLER_0_217 VPWR VGND sg13g2_decap_8
X_0908_ net103 VGND VPWR _0068_ daisychain\[4\] clknet_5_19__leaf_clk sg13g2_dfrbpq_1
Xoutput18 net18 uo_out[3] VPWR VGND sg13g2_buf_1
X_0839_ VPWR _0219_ daisychain\[26\] VGND sg13g2_inv_1
XFILLER_29_446 VPWR VGND sg13g2_decap_8
XFILLER_24_184 VPWR VGND sg13g2_decap_8
XFILLER_25_641 VPWR VGND sg13g2_decap_8
XFILLER_44_427 VPWR VGND sg13g2_decap_8
XFILLER_12_368 VPWR VGND sg13g2_decap_8
XFILLER_21_73 VPWR VGND sg13g2_decap_8
XFILLER_4_501 VPWR VGND sg13g2_decap_8
XFILLER_4_578 VPWR VGND sg13g2_decap_8
XFILLER_48_700 VPWR VGND sg13g2_decap_8
XFILLER_35_405 VPWR VGND sg13g2_decap_8
XFILLER_46_70 VPWR VGND sg13g2_decap_8
XFILLER_47_210 VPWR VGND sg13g2_decap_8
XFILLER_47_287 VPWR VGND sg13g2_decap_8
XFILLER_48_777 VPWR VGND sg13g2_decap_8
XFILLER_15_140 VPWR VGND sg13g2_decap_8
XFILLER_30_165 VPWR VGND sg13g2_decap_8
X_0624_ _0233_ net75 _0378_ _0379_ VPWR VGND sg13g2_a21o_1
XFILLER_7_42 VPWR VGND sg13g2_decap_8
XFILLER_7_350 VPWR VGND sg13g2_decap_8
XFILLER_38_210 VPWR VGND sg13g2_decap_8
XFILLER_39_722 VPWR VGND sg13g2_decap_8
X_0555_ net89 VPWR _0327_ VGND net66 state\[23\] sg13g2_o21ai_1
X_0486_ _0069_ _0274_ _0275_ net39 _0198_ VPWR VGND sg13g2_a22oi_1
XFILLER_22_622 VPWR VGND sg13g2_decap_8
XFILLER_26_427 VPWR VGND sg13g2_decap_8
XFILLER_38_287 VPWR VGND sg13g2_decap_8
XFILLER_21_143 VPWR VGND sg13g2_decap_8
XFILLER_42_28 VPWR VGND sg13g2_decap_8
XFILLER_1_504 VPWR VGND sg13g2_decap_8
XFILLER_49_508 VPWR VGND sg13g2_decap_8
XFILLER_17_416 VPWR VGND sg13g2_decap_8
XFILLER_29_243 VPWR VGND sg13g2_decap_8
XFILLER_44_224 VPWR VGND sg13g2_decap_8
XFILLER_12_165 VPWR VGND sg13g2_decap_8
XFILLER_13_600 VPWR VGND sg13g2_fill_2
XFILLER_13_644 VPWR VGND sg13g2_fill_2
XFILLER_16_84 VPWR VGND sg13g2_decap_8
XFILLER_40_441 VPWR VGND sg13g2_decap_8
XFILLER_9_648 VPWR VGND sg13g2_fill_2
XFILLER_8_147 VPWR VGND sg13g2_decap_8
XFILLER_4_375 VPWR VGND sg13g2_decap_8
XFILLER_0_581 VPWR VGND sg13g2_decap_8
XFILLER_23_419 VPWR VGND sg13g2_decap_8
XFILLER_35_202 VPWR VGND sg13g2_decap_8
XFILLER_35_279 VPWR VGND sg13g2_decap_8
XFILLER_48_574 VPWR VGND sg13g2_decap_8
XFILLER_31_452 VPWR VGND sg13g2_decap_8
X_0607_ net92 VPWR _0366_ VGND net69 state\[36\] sg13g2_o21ai_1
X_0538_ _0082_ _0313_ _0314_ net44 _0211_ VPWR VGND sg13g2_a22oi_1
XFILLER_26_224 VPWR VGND sg13g2_decap_8
XFILLER_27_769 VPWR VGND sg13g2_decap_8
XFILLER_39_585 VPWR VGND sg13g2_decap_8
X_0469_ VGND VPWR net23 daisychain\[0\] _0263_ net36 sg13g2_a21oi_1
XFILLER_14_419 VPWR VGND sg13g2_decap_8
XFILLER_41_238 VPWR VGND sg13g2_decap_8
XFILLER_1_301 VPWR VGND sg13g2_decap_8
XFILLER_22_496 VPWR VGND sg13g2_decap_8
XFILLER_1_378 VPWR VGND sg13g2_decap_8
XFILLER_49_305 VPWR VGND sg13g2_decap_8
XFILLER_17_213 VPWR VGND sg13g2_decap_8
XFILLER_27_83 VPWR VGND sg13g2_decap_8
XFILLER_45_511 VPWR VGND sg13g2_decap_8
XFILLER_45_588 VPWR VGND sg13g2_decap_8
XFILLER_13_496 VPWR VGND sg13g2_decap_8
XFILLER_32_249 VPWR VGND sg13g2_decap_8
XFILLER_9_445 VPWR VGND sg13g2_decap_8
XFILLER_5_684 VPWR VGND sg13g2_decap_4
XFILLER_4_32 VPWR VGND sg13g2_decap_8
XFILLER_4_172 VPWR VGND sg13g2_decap_8
XFILLER_36_500 VPWR VGND sg13g2_decap_8
XFILLER_48_371 VPWR VGND sg13g2_decap_8
XFILLER_23_216 VPWR VGND sg13g2_decap_8
XFILLER_36_577 VPWR VGND sg13g2_decap_8
XFILLER_2_109 VPWR VGND sg13g2_decap_8
XFILLER_48_49 VPWR VGND sg13g2_decap_8
XFILLER_14_216 VPWR VGND sg13g2_decap_8
XFILLER_15_739 VPWR VGND sg13g2_decap_4
XFILLER_27_566 VPWR VGND sg13g2_decap_8
XFILLER_39_371 VPWR VGND sg13g2_decap_8
XFILLER_42_525 VPWR VGND sg13g2_decap_8
XFILLER_46_308 VPWR VGND sg13g2_decap_8
XFILLER_10_466 VPWR VGND sg13g2_decap_8
XFILLER_13_41 VPWR VGND sg13g2_decap_8
XFILLER_22_293 VPWR VGND sg13g2_decap_8
Xfanout31 _0192_ net31 VPWR VGND sg13g2_buf_1
Xfanout97 net98 net97 VPWR VGND sg13g2_buf_1
Xfanout86 net100 net86 VPWR VGND sg13g2_buf_1
Xfanout75 net77 net75 VPWR VGND sg13g2_buf_1
Xfanout64 net65 net64 VPWR VGND sg13g2_buf_1
Xfanout53 net54 net53 VPWR VGND sg13g2_buf_1
Xfanout42 net45 net42 VPWR VGND sg13g2_buf_1
XFILLER_2_676 VPWR VGND sg13g2_decap_8
XFILLER_6_459 VPWR VGND sg13g2_decap_8
XFILLER_18_533 VPWR VGND sg13g2_decap_8
XFILLER_1_175 VPWR VGND sg13g2_decap_8
XFILLER_49_179 VPWR VGND sg13g2_decap_8
XFILLER_49_102 VPWR VGND sg13g2_decap_8
XFILLER_33_569 VPWR VGND sg13g2_decap_8
XFILLER_45_385 VPWR VGND sg13g2_decap_8
X_0941_ net115 VGND VPWR _0101_ daisychain\[37\] clknet_5_10__leaf_clk sg13g2_dfrbpq_1
XFILLER_13_293 VPWR VGND sg13g2_decap_8
X_0872_ VPWR _0002_ state\[43\] VGND sg13g2_inv_1
XFILLER_9_242 VPWR VGND sg13g2_decap_8
XFILLER_36_330 VPWR VGND sg13g2_decap_8
XFILLER_20_753 VPWR VGND sg13g2_decap_8
XFILLER_20_764 VPWR VGND sg13g2_fill_2
XFILLER_46_105 VPWR VGND sg13g2_decap_8
XFILLER_15_525 VPWR VGND sg13g2_decap_8
XFILLER_24_51 VPWR VGND sg13g2_decap_8
XFILLER_27_363 VPWR VGND sg13g2_decap_8
XFILLER_42_322 VPWR VGND sg13g2_decap_8
XFILLER_10_263 VPWR VGND sg13g2_decap_8
XFILLER_23_580 VPWR VGND sg13g2_decap_8
XFILLER_42_399 VPWR VGND sg13g2_decap_8
XFILLER_6_256 VPWR VGND sg13g2_decap_8
XFILLER_2_473 VPWR VGND sg13g2_decap_8
XFILLER_49_81 VPWR VGND sg13g2_decap_8
XFILLER_18_374 VPWR VGND sg13g2_decap_8
XFILLER_1_77 VPWR VGND sg13g2_decap_8
XFILLER_37_138 VPWR VGND sg13g2_decap_8
XFILLER_46_672 VPWR VGND sg13g2_decap_8
XFILLER_14_580 VPWR VGND sg13g2_decap_8
XFILLER_21_528 VPWR VGND sg13g2_decap_8
XFILLER_33_366 VPWR VGND sg13g2_decap_8
XFILLER_45_182 VPWR VGND sg13g2_decap_8
X_0924_ net109 VGND VPWR _0084_ daisychain\[20\] clknet_5_4__leaf_clk sg13g2_dfrbpq_1
X_0855_ VPWR _0227_ daisychain\[34\] VGND sg13g2_inv_1
X_0786_ VPWR _0032_ state\[0\] VGND sg13g2_inv_1
XFILLER_28_138 VPWR VGND sg13g2_decap_8
XFILLER_29_628 VPWR VGND sg13g2_decap_4
XFILLER_24_366 VPWR VGND sg13g2_decap_8
XFILLER_43_119 VPWR VGND sg13g2_decap_8
XFILLER_44_609 VPWR VGND sg13g2_decap_8
XFILLER_45_28 VPWR VGND sg13g2_decap_8
XFILLER_10_53 VPWR VGND sg13g2_decap_8
XFILLER_4_727 VPWR VGND sg13g2_decap_4
XFILLER_19_127 VPWR VGND sg13g2_decap_8
XFILLER_27_160 VPWR VGND sg13g2_decap_8
XFILLER_28_661 VPWR VGND sg13g2_fill_1
XFILLER_34_119 VPWR VGND sg13g2_decap_8
XFILLER_47_469 VPWR VGND sg13g2_decap_8
XFILLER_11_550 VPWR VGND sg13g2_decap_8
XFILLER_15_322 VPWR VGND sg13g2_decap_8
XFILLER_15_399 VPWR VGND sg13g2_decap_8
XFILLER_30_347 VPWR VGND sg13g2_decap_8
XFILLER_35_83 VPWR VGND sg13g2_decap_8
XFILLER_42_196 VPWR VGND sg13g2_decap_8
X_0640_ _0237_ net73 _0390_ _0391_ VPWR VGND sg13g2_a21o_1
X_0571_ net84 VPWR _0339_ VGND net61 state\[27\] sg13g2_o21ai_1
XFILLER_7_532 VPWR VGND sg13g2_decap_8
XFILLER_25_4 VPWR VGND sg13g2_decap_4
XFILLER_2_270 VPWR VGND sg13g2_decap_8
XFILLER_18_171 VPWR VGND sg13g2_decap_8
XFILLER_19_672 VPWR VGND sg13g2_fill_1
XFILLER_26_609 VPWR VGND sg13g2_decap_8
XFILLER_33_163 VPWR VGND sg13g2_decap_8
XFILLER_38_458 VPWR VGND sg13g2_decap_8
X_1054_ daisychain\[62\] net21 VPWR VGND sg13g2_buf_1
XFILLER_21_325 VPWR VGND sg13g2_decap_8
X_0907_ net103 VGND VPWR _0067_ daisychain\[3\] clknet_5_18__leaf_clk sg13g2_dfrbpq_1
Xoutput19 net19 uo_out[4] VPWR VGND sg13g2_buf_1
X_0838_ VPWR _0050_ state\[26\] VGND sg13g2_inv_1
X_0769_ _0406_ VPWR _0177_ VGND net98 _0008_ sg13g2_o21ai_1
XFILLER_16_119 VPWR VGND sg13g2_decap_8
XFILLER_29_425 VPWR VGND sg13g2_decap_8
XFILLER_44_406 VPWR VGND sg13g2_decap_8
XFILLER_12_347 VPWR VGND sg13g2_decap_8
XFILLER_24_163 VPWR VGND sg13g2_decap_8
XFILLER_25_620 VPWR VGND sg13g2_decap_8
XFILLER_37_491 VPWR VGND sg13g2_fill_1
XFILLER_20_391 VPWR VGND sg13g2_decap_8
XFILLER_21_52 VPWR VGND sg13g2_decap_8
XFILLER_8_329 VPWR VGND sg13g2_decap_8
XFILLER_4_557 VPWR VGND sg13g2_decap_8
XFILLER_0_774 VPWR VGND sg13g2_fill_1
XFILLER_0_796 VPWR VGND sg13g2_decap_4
XFILLER_47_266 VPWR VGND sg13g2_decap_8
XFILLER_48_756 VPWR VGND sg13g2_decap_8
XFILLER_15_196 VPWR VGND sg13g2_decap_8
XFILLER_30_144 VPWR VGND sg13g2_decap_8
XFILLER_43_483 VPWR VGND sg13g2_decap_8
XFILLER_7_21 VPWR VGND sg13g2_decap_8
X_0623_ net97 VPWR _0378_ VGND net75 state\[40\] sg13g2_o21ai_1
X_0554_ _0086_ _0325_ _0326_ net43 _0215_ VPWR VGND sg13g2_a22oi_1
XFILLER_7_98 VPWR VGND sg13g2_decap_8
XFILLER_26_406 VPWR VGND sg13g2_decap_8
XFILLER_38_266 VPWR VGND sg13g2_decap_8
X_0485_ VGND VPWR net23 daisychain\[4\] _0275_ net39 sg13g2_a21oi_1
XFILLER_19_491 VPWR VGND sg13g2_decap_8
XFILLER_21_122 VPWR VGND sg13g2_decap_8
XFILLER_22_601 VPWR VGND sg13g2_decap_8
XFILLER_34_483 VPWR VGND sg13g2_decap_8
XFILLER_21_199 VPWR VGND sg13g2_decap_8
XFILLER_22_689 VPWR VGND sg13g2_decap_4
XFILLER_29_222 VPWR VGND sg13g2_decap_8
XFILLER_29_299 VPWR VGND sg13g2_decap_8
XFILLER_44_203 VPWR VGND sg13g2_decap_8
XFILLER_12_144 VPWR VGND sg13g2_decap_8
XFILLER_16_63 VPWR VGND sg13g2_decap_8
XFILLER_25_494 VPWR VGND sg13g2_decap_8
XFILLER_40_420 VPWR VGND sg13g2_decap_8
XFILLER_40_497 VPWR VGND sg13g2_decap_8
XFILLER_9_627 VPWR VGND sg13g2_decap_4
XFILLER_8_126 VPWR VGND sg13g2_decap_8
XFILLER_32_95 VPWR VGND sg13g2_decap_8
XFILLER_4_354 VPWR VGND sg13g2_decap_8
XFILLER_0_560 VPWR VGND sg13g2_decap_8
XFILLER_48_553 VPWR VGND sg13g2_decap_8
XFILLER_16_483 VPWR VGND sg13g2_decap_8
XFILLER_31_431 VPWR VGND sg13g2_decap_8
XFILLER_35_258 VPWR VGND sg13g2_decap_8
XFILLER_43_280 VPWR VGND sg13g2_decap_8
X_0606_ _0099_ _0364_ _0365_ net46 _0228_ VPWR VGND sg13g2_a22oi_1
X_0537_ VGND VPWR net26 daisychain\[17\] _0314_ net44 sg13g2_a21oi_1
XFILLER_26_203 VPWR VGND sg13g2_decap_8
XFILLER_27_715 VPWR VGND sg13g2_decap_8
X_0468_ _0194_ net59 _0261_ _0262_ VPWR VGND sg13g2_a21o_1
XFILLER_22_475 VPWR VGND sg13g2_decap_8
XFILLER_34_280 VPWR VGND sg13g2_decap_8
XFILLER_41_217 VPWR VGND sg13g2_decap_8
Xclkbuf_5_13__f_clk clknet_5_13__leaf_clk clknet_4_6_0_clk VPWR VGND sg13g2_buf_16
XFILLER_18_715 VPWR VGND sg13g2_fill_1
XFILLER_1_357 VPWR VGND sg13g2_decap_8
XFILLER_17_269 VPWR VGND sg13g2_decap_8
XFILLER_25_291 VPWR VGND sg13g2_decap_8
XFILLER_27_62 VPWR VGND sg13g2_decap_8
XFILLER_32_228 VPWR VGND sg13g2_decap_8
XFILLER_45_567 VPWR VGND sg13g2_decap_8
XFILLER_13_475 VPWR VGND sg13g2_decap_8
XFILLER_40_294 VPWR VGND sg13g2_decap_8
XFILLER_9_424 VPWR VGND sg13g2_decap_8
XFILLER_4_88 VPWR VGND sg13g2_decap_8
XFILLER_4_151 VPWR VGND sg13g2_decap_8
XFILLER_4_11 VPWR VGND sg13g2_decap_8
XFILLER_36_556 VPWR VGND sg13g2_decap_8
XFILLER_48_350 VPWR VGND sg13g2_decap_8
XFILLER_16_280 VPWR VGND sg13g2_decap_8
XFILLER_32_762 VPWR VGND sg13g2_decap_8
XFILLER_8_490 VPWR VGND sg13g2_decap_8
XFILLER_39_350 VPWR VGND sg13g2_decap_8
XFILLER_48_28 VPWR VGND sg13g2_decap_8
XFILLER_27_545 VPWR VGND sg13g2_decap_8
XFILLER_42_504 VPWR VGND sg13g2_decap_8
XFILLER_10_445 VPWR VGND sg13g2_decap_8
XFILLER_13_20 VPWR VGND sg13g2_decap_8
XFILLER_13_97 VPWR VGND sg13g2_decap_8
XFILLER_22_272 VPWR VGND sg13g2_decap_8
Xfanout32 _0192_ net32 VPWR VGND sg13g2_buf_1
Xfanout98 net99 net98 VPWR VGND sg13g2_buf_1
Xfanout87 net88 net87 VPWR VGND sg13g2_buf_1
Xfanout76 net77 net76 VPWR VGND sg13g2_buf_1
Xfanout65 net68 net65 VPWR VGND sg13g2_buf_1
Xfanout54 net55 net54 VPWR VGND sg13g2_buf_1
Xfanout43 net45 net43 VPWR VGND sg13g2_buf_1
XFILLER_6_438 VPWR VGND sg13g2_decap_8
XFILLER_1_154 VPWR VGND sg13g2_decap_8
XFILLER_2_655 VPWR VGND sg13g2_decap_8
XFILLER_2_699 VPWR VGND sg13g2_fill_1
XFILLER_49_158 VPWR VGND sg13g2_decap_8
XFILLER_13_272 VPWR VGND sg13g2_decap_8
XFILLER_20_209 VPWR VGND sg13g2_decap_8
XFILLER_33_548 VPWR VGND sg13g2_decap_8
XFILLER_41_581 VPWR VGND sg13g2_decap_8
XFILLER_45_364 VPWR VGND sg13g2_decap_8
X_0940_ net115 VGND VPWR _0100_ daisychain\[36\] clknet_5_9__leaf_clk sg13g2_dfrbpq_1
XFILLER_9_221 VPWR VGND sg13g2_decap_8
X_0871_ VPWR _0235_ daisychain\[42\] VGND sg13g2_inv_1
XFILLER_9_298 VPWR VGND sg13g2_decap_8
XFILLER_24_559 VPWR VGND sg13g2_decap_8
XFILLER_32_592 VPWR VGND sg13g2_decap_4
XFILLER_19_309 VPWR VGND sg13g2_decap_8
XFILLER_27_342 VPWR VGND sg13g2_decap_8
XFILLER_15_504 VPWR VGND sg13g2_decap_8
XFILLER_24_30 VPWR VGND sg13g2_decap_8
XFILLER_30_529 VPWR VGND sg13g2_decap_8
XFILLER_42_301 VPWR VGND sg13g2_decap_8
XFILLER_42_378 VPWR VGND sg13g2_decap_8
XFILLER_10_242 VPWR VGND sg13g2_decap_8
XFILLER_40_84 VPWR VGND sg13g2_decap_8
XFILLER_7_736 VPWR VGND sg13g2_fill_1
XFILLER_6_235 VPWR VGND sg13g2_decap_8
XFILLER_27_8 VPWR VGND sg13g2_fill_1
XFILLER_2_452 VPWR VGND sg13g2_decap_8
XFILLER_38_618 VPWR VGND sg13g2_fill_2
XFILLER_49_60 VPWR VGND sg13g2_decap_8
XFILLER_18_353 VPWR VGND sg13g2_decap_8
XFILLER_1_56 VPWR VGND sg13g2_decap_8
XFILLER_33_345 VPWR VGND sg13g2_decap_8
XFILLER_37_117 VPWR VGND sg13g2_decap_8
XFILLER_45_161 VPWR VGND sg13g2_decap_8
XFILLER_46_651 VPWR VGND sg13g2_decap_8
XFILLER_21_507 VPWR VGND sg13g2_decap_8
X_0923_ net117 VGND VPWR _0083_ daisychain\[19\] clknet_5_5__leaf_clk sg13g2_dfrbpq_1
X_0854_ VPWR _0022_ state\[34\] VGND sg13g2_inv_1
XFILLER_46_0 VPWR VGND sg13g2_decap_8
X_0785_ VPWR _0192_ net80 VGND sg13g2_inv_1
XFILLER_28_117 VPWR VGND sg13g2_decap_8
XFILLER_29_607 VPWR VGND sg13g2_decap_8
XFILLER_12_529 VPWR VGND sg13g2_decap_8
XFILLER_24_345 VPWR VGND sg13g2_decap_8
XFILLER_36_183 VPWR VGND sg13g2_decap_8
XFILLER_37_673 VPWR VGND sg13g2_decap_8
XFILLER_37_695 VPWR VGND sg13g2_fill_2
XFILLER_10_32 VPWR VGND sg13g2_decap_8
XFILLER_3_249 VPWR VGND sg13g2_decap_8
XFILLER_15_301 VPWR VGND sg13g2_decap_8
XFILLER_19_106 VPWR VGND sg13g2_decap_8
XFILLER_19_85 VPWR VGND sg13g2_decap_8
XFILLER_47_448 VPWR VGND sg13g2_decap_8
XFILLER_15_378 VPWR VGND sg13g2_decap_8
XFILLER_30_326 VPWR VGND sg13g2_decap_8
XFILLER_35_62 VPWR VGND sg13g2_decap_8
XFILLER_42_175 VPWR VGND sg13g2_decap_8
XFILLER_7_511 VPWR VGND sg13g2_decap_8
X_0570_ _0090_ _0337_ _0338_ net37 _0219_ VPWR VGND sg13g2_a22oi_1
XFILLER_7_588 VPWR VGND sg13g2_decap_8
XFILLER_18_4 VPWR VGND sg13g2_decap_4
XFILLER_19_651 VPWR VGND sg13g2_decap_8
XFILLER_38_437 VPWR VGND sg13g2_decap_8
XFILLER_18_150 VPWR VGND sg13g2_decap_8
XFILLER_21_304 VPWR VGND sg13g2_decap_8
XFILLER_25_109 VPWR VGND sg13g2_decap_8
XFILLER_33_142 VPWR VGND sg13g2_decap_8
XFILLER_34_621 VPWR VGND sg13g2_fill_1
XFILLER_34_676 VPWR VGND sg13g2_decap_4
X_1053_ daisychain\[61\] net20 VPWR VGND sg13g2_buf_1
X_0906_ net101 VGND VPWR _0066_ daisychain\[2\] clknet_5_18__leaf_clk sg13g2_dfrbpq_1
X_0837_ VPWR _0218_ daisychain\[25\] VGND sg13g2_inv_1
X_0768_ _0403_ VPWR _0176_ VGND net98 _0007_ sg13g2_o21ai_1
X_0699_ net80 VPWR _0435_ VGND net57 state\[59\] sg13g2_o21ai_1
XFILLER_29_404 VPWR VGND sg13g2_decap_8
XFILLER_37_470 VPWR VGND sg13g2_decap_8
XFILLER_12_326 VPWR VGND sg13g2_decap_8
XFILLER_24_142 VPWR VGND sg13g2_decap_8
XFILLER_40_602 VPWR VGND sg13g2_decap_8
XFILLER_8_308 VPWR VGND sg13g2_decap_8
XFILLER_20_370 VPWR VGND sg13g2_decap_8
XFILLER_21_31 VPWR VGND sg13g2_decap_8
XFILLER_4_536 VPWR VGND sg13g2_decap_8
XFILLER_0_753 VPWR VGND sg13g2_fill_1
XFILLER_47_245 VPWR VGND sg13g2_decap_8
XFILLER_48_735 VPWR VGND sg13g2_decap_8
XFILLER_15_175 VPWR VGND sg13g2_decap_8
XFILLER_28_481 VPWR VGND sg13g2_decap_8
XFILLER_43_462 VPWR VGND sg13g2_decap_8
XFILLER_30_123 VPWR VGND sg13g2_decap_8
XFILLER_7_77 VPWR VGND sg13g2_decap_8
X_0622_ _0103_ _0376_ _0377_ net52 _0232_ VPWR VGND sg13g2_a22oi_1
X_0553_ VGND VPWR net26 daisychain\[21\] _0326_ net43 sg13g2_a21oi_1
X_0484_ _0198_ net60 _0273_ _0274_ VPWR VGND sg13g2_a21o_1
XFILLER_7_385 VPWR VGND sg13g2_decap_8
XFILLER_19_470 VPWR VGND sg13g2_decap_8
XFILLER_38_245 VPWR VGND sg13g2_decap_8
XFILLER_21_101 VPWR VGND sg13g2_decap_8
XFILLER_21_178 VPWR VGND sg13g2_decap_8
XFILLER_34_462 VPWR VGND sg13g2_decap_8
XFILLER_1_539 VPWR VGND sg13g2_decap_8
XFILLER_29_201 VPWR VGND sg13g2_decap_8
XFILLER_16_42 VPWR VGND sg13g2_decap_8
XFILLER_25_473 VPWR VGND sg13g2_decap_8
XFILLER_29_278 VPWR VGND sg13g2_decap_8
XFILLER_44_259 VPWR VGND sg13g2_decap_8
XFILLER_45_749 VPWR VGND sg13g2_fill_2
XFILLER_12_123 VPWR VGND sg13g2_decap_8
XFILLER_32_74 VPWR VGND sg13g2_decap_8
XFILLER_40_476 VPWR VGND sg13g2_decap_8
XFILLER_8_105 VPWR VGND sg13g2_decap_8
XFILLER_4_333 VPWR VGND sg13g2_decap_8
XFILLER_35_237 VPWR VGND sg13g2_decap_8
XFILLER_36_705 VPWR VGND sg13g2_fill_1
XFILLER_48_532 VPWR VGND sg13g2_decap_8
XFILLER_16_462 VPWR VGND sg13g2_decap_8
XFILLER_31_410 VPWR VGND sg13g2_decap_8
XFILLER_31_487 VPWR VGND sg13g2_decap_8
XFILLER_7_182 VPWR VGND sg13g2_decap_8
XFILLER_39_521 VPWR VGND sg13g2_fill_1
X_0605_ VGND VPWR net28 daisychain\[34\] _0365_ net46 sg13g2_a21oi_1
X_0536_ _0211_ net68 _0312_ _0313_ VPWR VGND sg13g2_a21o_1
X_0467_ net82 VPWR _0261_ VGND net59 state\[1\] sg13g2_o21ai_1
XFILLER_26_259 VPWR VGND sg13g2_decap_8
X_1019_ net119 VGND VPWR _0179_ state\[51\] clknet_5_15__leaf_clk sg13g2_dfrbpq_1
XFILLER_10_605 VPWR VGND sg13g2_decap_8
XFILLER_22_454 VPWR VGND sg13g2_decap_8
XFILLER_1_336 VPWR VGND sg13g2_decap_8
XFILLER_27_41 VPWR VGND sg13g2_decap_8
XFILLER_45_546 VPWR VGND sg13g2_decap_8
XFILLER_13_454 VPWR VGND sg13g2_decap_8
XFILLER_17_248 VPWR VGND sg13g2_decap_8
XFILLER_25_270 VPWR VGND sg13g2_decap_8
XFILLER_32_207 VPWR VGND sg13g2_decap_8
XFILLER_9_403 VPWR VGND sg13g2_decap_8
XFILLER_40_273 VPWR VGND sg13g2_decap_8
XFILLER_43_84 VPWR VGND sg13g2_decap_8
XFILLER_5_653 VPWR VGND sg13g2_fill_2
XFILLER_5_620 VPWR VGND sg13g2_decap_8
XFILLER_4_130 VPWR VGND sg13g2_decap_8
XFILLER_4_67 VPWR VGND sg13g2_decap_8
XFILLER_36_535 VPWR VGND sg13g2_decap_8
XFILLER_31_284 VPWR VGND sg13g2_decap_8
XFILLER_27_524 VPWR VGND sg13g2_decap_8
X_0519_ net88 VPWR _0300_ VGND net65 state\[14\] sg13g2_o21ai_1
XFILLER_22_251 VPWR VGND sg13g2_decap_8
Xfanout33 net35 net33 VPWR VGND sg13g2_buf_1
Xfanout55 _0259_ net55 VPWR VGND sg13g2_buf_1
Xfanout44 net45 net44 VPWR VGND sg13g2_buf_1
XFILLER_10_424 VPWR VGND sg13g2_decap_8
XFILLER_13_76 VPWR VGND sg13g2_decap_8
Xfanout99 net100 net99 VPWR VGND sg13g2_buf_1
Xfanout88 net91 net88 VPWR VGND sg13g2_buf_1
Xfanout77 net78 net77 VPWR VGND sg13g2_buf_1
Xfanout66 net67 net66 VPWR VGND sg13g2_buf_1
XFILLER_6_417 VPWR VGND sg13g2_decap_8
XFILLER_1_133 VPWR VGND sg13g2_decap_8
XFILLER_2_634 VPWR VGND sg13g2_decap_8
XFILLER_49_137 VPWR VGND sg13g2_decap_8
XFILLER_33_527 VPWR VGND sg13g2_decap_8
XFILLER_38_84 VPWR VGND sg13g2_decap_8
XFILLER_45_343 VPWR VGND sg13g2_decap_8
XFILLER_13_251 VPWR VGND sg13g2_decap_8
XFILLER_41_560 VPWR VGND sg13g2_decap_8
X_0870_ VPWR _0001_ state\[42\] VGND sg13g2_inv_1
XFILLER_9_277 VPWR VGND sg13g2_decap_8
XFILLER_9_200 VPWR VGND sg13g2_decap_8
XFILLER_5_494 VPWR VGND sg13g2_decap_8
XFILLER_24_538 VPWR VGND sg13g2_decap_8
XFILLER_36_365 VPWR VGND sg13g2_decap_8
XFILLER_36_376 VPWR VGND sg13g2_fill_2
XFILLER_20_777 VPWR VGND sg13g2_decap_8
XFILLER_32_571 VPWR VGND sg13g2_decap_8
X_0999_ net113 VGND VPWR _0159_ state\[31\] clknet_5_4__leaf_clk sg13g2_dfrbpq_1
XFILLER_27_321 VPWR VGND sg13g2_decap_8
XFILLER_10_221 VPWR VGND sg13g2_decap_8
XFILLER_24_86 VPWR VGND sg13g2_decap_8
XFILLER_27_398 VPWR VGND sg13g2_decap_8
XFILLER_30_508 VPWR VGND sg13g2_decap_8
XFILLER_42_357 VPWR VGND sg13g2_decap_8
XFILLER_10_298 VPWR VGND sg13g2_decap_8
XFILLER_2_431 VPWR VGND sg13g2_decap_8
XFILLER_40_63 VPWR VGND sg13g2_decap_8
XFILLER_7_726 VPWR VGND sg13g2_fill_2
XFILLER_6_214 VPWR VGND sg13g2_decap_8
XFILLER_1_35 VPWR VGND sg13g2_decap_8
XFILLER_18_332 VPWR VGND sg13g2_decap_8
XFILLER_33_324 VPWR VGND sg13g2_decap_8
XFILLER_45_140 VPWR VGND sg13g2_decap_8
XFILLER_46_630 VPWR VGND sg13g2_decap_8
X_0922_ net110 VGND VPWR _0082_ daisychain\[18\] clknet_5_30__leaf_clk sg13g2_dfrbpq_1
X_0853_ VPWR _0226_ daisychain\[33\] VGND sg13g2_inv_1
XFILLER_39_0 VPWR VGND sg13g2_decap_8
X_0784_ _0449_ VPWR _0191_ VGND net81 _0024_ sg13g2_o21ai_1
XFILLER_5_291 VPWR VGND sg13g2_decap_8
XFILLER_25_814 VPWR VGND sg13g2_decap_8
XFILLER_36_162 VPWR VGND sg13g2_decap_8
Xinput1 rst_n net1 VPWR VGND sg13g2_buf_1
XFILLER_12_508 VPWR VGND sg13g2_decap_8
XFILLER_24_324 VPWR VGND sg13g2_decap_8
XFILLER_10_11 VPWR VGND sg13g2_decap_8
XFILLER_20_596 VPWR VGND sg13g2_decap_8
XFILLER_3_228 VPWR VGND sg13g2_decap_8
XFILLER_10_88 VPWR VGND sg13g2_decap_8
XFILLER_19_64 VPWR VGND sg13g2_decap_8
XFILLER_47_427 VPWR VGND sg13g2_decap_8
XFILLER_15_357 VPWR VGND sg13g2_decap_8
XFILLER_27_195 VPWR VGND sg13g2_decap_8
XFILLER_31_806 VPWR VGND sg13g2_decap_8
XFILLER_35_41 VPWR VGND sg13g2_decap_8
XFILLER_42_154 VPWR VGND sg13g2_decap_8
XFILLER_43_644 VPWR VGND sg13g2_decap_8
XFILLER_30_305 VPWR VGND sg13g2_decap_8
XFILLER_7_567 VPWR VGND sg13g2_decap_8
XFILLER_19_641 VPWR VGND sg13g2_fill_2
XFILLER_38_416 VPWR VGND sg13g2_decap_8
X_1052_ daisychain\[60\] net19 VPWR VGND sg13g2_buf_1
XFILLER_33_121 VPWR VGND sg13g2_decap_8
XFILLER_33_198 VPWR VGND sg13g2_decap_8
X_0905_ net103 VGND VPWR _0065_ daisychain\[1\] clknet_5_25__leaf_clk sg13g2_dfrbpq_1
X_0836_ VPWR _0049_ state\[25\] VGND sg13g2_inv_1
X_0767_ _0400_ VPWR _0175_ VGND net96 _0006_ sg13g2_o21ai_1
X_0698_ _0122_ _0433_ _0434_ net33 _0251_ VPWR VGND sg13g2_a22oi_1
XFILLER_24_121 VPWR VGND sg13g2_decap_8
XFILLER_25_655 VPWR VGND sg13g2_decap_8
XFILLER_12_305 VPWR VGND sg13g2_decap_8
XFILLER_24_198 VPWR VGND sg13g2_decap_8
XFILLER_21_87 VPWR VGND sg13g2_decap_8
XFILLER_4_515 VPWR VGND sg13g2_decap_8
XFILLER_0_765 VPWR VGND sg13g2_decap_8
XFILLER_28_460 VPWR VGND sg13g2_decap_8
XFILLER_35_419 VPWR VGND sg13g2_decap_8
XFILLER_47_224 VPWR VGND sg13g2_decap_8
XFILLER_48_714 VPWR VGND sg13g2_decap_8
XFILLER_15_154 VPWR VGND sg13g2_decap_8
XFILLER_30_102 VPWR VGND sg13g2_decap_8
XFILLER_31_658 VPWR VGND sg13g2_fill_1
XFILLER_43_441 VPWR VGND sg13g2_decap_8
XFILLER_46_84 VPWR VGND sg13g2_decap_8
Xclkbuf_5_0__f_clk clknet_5_0__leaf_clk clknet_4_0_0_clk VPWR VGND sg13g2_buf_16
XFILLER_11_382 VPWR VGND sg13g2_decap_8
XFILLER_30_179 VPWR VGND sg13g2_decap_8
X_0621_ VGND VPWR net28 daisychain\[38\] _0377_ net48 sg13g2_a21oi_1
XFILLER_7_56 VPWR VGND sg13g2_decap_8
XFILLER_7_364 VPWR VGND sg13g2_decap_8
XFILLER_30_4 VPWR VGND sg13g2_decap_4
XFILLER_3_592 VPWR VGND sg13g2_decap_8
X_0552_ _0215_ net67 _0324_ _0325_ VPWR VGND sg13g2_a21o_1
X_0483_ net82 VPWR _0273_ VGND net60 state\[5\] sg13g2_o21ai_1
XFILLER_34_441 VPWR VGND sg13g2_decap_8
XFILLER_38_224 VPWR VGND sg13g2_decap_8
XFILLER_47_791 VPWR VGND sg13g2_decap_8
XFILLER_21_157 VPWR VGND sg13g2_decap_8
XFILLER_22_636 VPWR VGND sg13g2_decap_8
XFILLER_1_518 VPWR VGND sg13g2_decap_8
X_0819_ VPWR _0209_ daisychain\[16\] VGND sg13g2_inv_1
XFILLER_29_257 VPWR VGND sg13g2_decap_8
XFILLER_12_102 VPWR VGND sg13g2_decap_8
XFILLER_13_614 VPWR VGND sg13g2_decap_8
XFILLER_16_98 VPWR VGND sg13g2_decap_8
XFILLER_25_452 VPWR VGND sg13g2_decap_8
XFILLER_44_238 VPWR VGND sg13g2_decap_8
XFILLER_12_179 VPWR VGND sg13g2_decap_8
XFILLER_32_53 VPWR VGND sg13g2_decap_8
XFILLER_40_455 VPWR VGND sg13g2_decap_8
XFILLER_4_312 VPWR VGND sg13g2_decap_8
XFILLER_48_511 VPWR VGND sg13g2_decap_8
XFILLER_4_389 VPWR VGND sg13g2_decap_8
XFILLER_0_595 VPWR VGND sg13g2_decap_8
XFILLER_16_441 VPWR VGND sg13g2_decap_8
XFILLER_35_216 VPWR VGND sg13g2_decap_8
XFILLER_48_588 VPWR VGND sg13g2_decap_8
XFILLER_31_466 VPWR VGND sg13g2_decap_8
X_0604_ _0228_ net69 _0363_ _0364_ VPWR VGND sg13g2_a21o_1
XFILLER_7_161 VPWR VGND sg13g2_decap_8
X_0535_ net90 VPWR _0312_ VGND net67 state\[18\] sg13g2_o21ai_1
X_0466_ _0064_ _0260_ _0258_ net55 _0193_ VPWR VGND sg13g2_a22oi_1
XFILLER_22_433 VPWR VGND sg13g2_decap_8
XFILLER_26_238 VPWR VGND sg13g2_decap_8
XFILLER_39_599 VPWR VGND sg13g2_decap_8
X_1018_ net120 VGND VPWR _0178_ state\[50\] clknet_5_15__leaf_clk sg13g2_dfrbpq_1
XFILLER_5_109 VPWR VGND sg13g2_decap_8
XFILLER_1_315 VPWR VGND sg13g2_decap_8
XFILLER_49_319 VPWR VGND sg13g2_decap_8
XFILLER_17_227 VPWR VGND sg13g2_decap_8
XFILLER_45_525 VPWR VGND sg13g2_decap_8
XFILLER_13_433 VPWR VGND sg13g2_decap_8
XFILLER_27_97 VPWR VGND sg13g2_decap_8
XFILLER_40_252 VPWR VGND sg13g2_decap_8
XFILLER_43_63 VPWR VGND sg13g2_decap_8
XFILLER_9_459 VPWR VGND sg13g2_decap_8
XFILLER_0_392 VPWR VGND sg13g2_decap_8
XFILLER_4_46 VPWR VGND sg13g2_decap_8
XFILLER_4_186 VPWR VGND sg13g2_decap_8
XFILLER_36_514 VPWR VGND sg13g2_decap_8
XFILLER_48_385 VPWR VGND sg13g2_decap_8
XFILLER_31_263 VPWR VGND sg13g2_decap_8
X_0518_ _0077_ _0298_ _0299_ net41 _0206_ VPWR VGND sg13g2_a22oi_1
XFILLER_27_503 VPWR VGND sg13g2_decap_8
XFILLER_39_385 VPWR VGND sg13g2_decap_8
XFILLER_10_403 VPWR VGND sg13g2_decap_8
XFILLER_22_230 VPWR VGND sg13g2_decap_8
XFILLER_35_580 VPWR VGND sg13g2_decap_8
XFILLER_42_539 VPWR VGND sg13g2_decap_8
Xfanout23 net27 net23 VPWR VGND sg13g2_buf_1
Xfanout34 net35 net34 VPWR VGND sg13g2_buf_1
Xfanout89 net90 net89 VPWR VGND sg13g2_buf_1
Xfanout78 net79 net78 VPWR VGND sg13g2_buf_1
Xfanout67 net68 net67 VPWR VGND sg13g2_buf_1
Xfanout56 net58 net56 VPWR VGND sg13g2_buf_1
Xfanout45 net55 net45 VPWR VGND sg13g2_buf_1
XFILLER_13_55 VPWR VGND sg13g2_decap_8
XFILLER_2_613 VPWR VGND sg13g2_decap_8
XFILLER_1_112 VPWR VGND sg13g2_decap_8
XFILLER_1_189 VPWR VGND sg13g2_decap_8
XFILLER_38_63 VPWR VGND sg13g2_decap_8
XFILLER_8_4 VPWR VGND sg13g2_decap_4
XFILLER_49_116 VPWR VGND sg13g2_decap_8
XFILLER_18_547 VPWR VGND sg13g2_decap_8
XFILLER_33_506 VPWR VGND sg13g2_decap_8
XFILLER_45_322 VPWR VGND sg13g2_decap_8
XFILLER_45_399 VPWR VGND sg13g2_decap_8
XFILLER_13_230 VPWR VGND sg13g2_decap_8
XFILLER_9_256 VPWR VGND sg13g2_decap_8
XFILLER_5_473 VPWR VGND sg13g2_decap_8
XFILLER_36_344 VPWR VGND sg13g2_decap_8
XFILLER_48_182 VPWR VGND sg13g2_decap_8
XFILLER_49_683 VPWR VGND sg13g2_decap_8
XFILLER_17_591 VPWR VGND sg13g2_decap_4
XFILLER_32_550 VPWR VGND sg13g2_decap_8
XFILLER_36_388 VPWR VGND sg13g2_decap_8
X_0998_ net106 VGND VPWR _0158_ state\[30\] clknet_5_27__leaf_clk sg13g2_dfrbpq_1
XFILLER_47_609 VPWR VGND sg13g2_decap_8
XFILLER_15_539 VPWR VGND sg13g2_decap_8
XFILLER_27_300 VPWR VGND sg13g2_decap_8
XFILLER_27_377 VPWR VGND sg13g2_decap_8
XFILLER_28_812 VPWR VGND sg13g2_decap_8
XFILLER_39_182 VPWR VGND sg13g2_decap_8
XFILLER_42_336 VPWR VGND sg13g2_decap_8
XFILLER_46_119 VPWR VGND sg13g2_decap_8
XFILLER_10_200 VPWR VGND sg13g2_decap_8
XFILLER_10_277 VPWR VGND sg13g2_decap_8
XFILLER_23_594 VPWR VGND sg13g2_decap_8
XFILLER_24_65 VPWR VGND sg13g2_decap_8
XFILLER_2_410 VPWR VGND sg13g2_decap_8
XFILLER_40_42 VPWR VGND sg13g2_decap_8
XFILLER_18_311 VPWR VGND sg13g2_decap_8
XFILLER_1_14 VPWR VGND sg13g2_decap_8
XFILLER_2_487 VPWR VGND sg13g2_decap_8
XFILLER_49_95 VPWR VGND sg13g2_decap_8
XFILLER_18_388 VPWR VGND sg13g2_decap_8
XFILLER_33_303 VPWR VGND sg13g2_decap_8
XFILLER_45_196 VPWR VGND sg13g2_decap_8
XFILLER_46_686 VPWR VGND sg13g2_decap_8
X_0921_ net109 VGND VPWR _0081_ daisychain\[17\] clknet_5_31__leaf_clk sg13g2_dfrbpq_1
XFILLER_14_594 VPWR VGND sg13g2_decap_8
X_0852_ VPWR _0011_ state\[33\] VGND sg13g2_inv_1
X_0783_ _0451_ VPWR _0190_ VGND _0444_ _0445_ sg13g2_o21ai_1
XFILLER_5_270 VPWR VGND sg13g2_decap_8
XFILLER_24_303 VPWR VGND sg13g2_decap_8
XFILLER_36_141 VPWR VGND sg13g2_decap_8
Xinput2 ui_in[0] net2 VPWR VGND sg13g2_buf_1
XFILLER_49_480 VPWR VGND sg13g2_decap_8
XFILLER_20_575 VPWR VGND sg13g2_decap_8
XFILLER_10_67 VPWR VGND sg13g2_decap_8
XFILLER_3_207 VPWR VGND sg13g2_decap_8
XFILLER_19_43 VPWR VGND sg13g2_decap_8
XFILLER_28_642 VPWR VGND sg13g2_decap_8
XFILLER_47_406 VPWR VGND sg13g2_decap_8
XFILLER_15_336 VPWR VGND sg13g2_decap_8
XFILLER_27_174 VPWR VGND sg13g2_decap_8
XFILLER_35_20 VPWR VGND sg13g2_decap_8
XFILLER_35_97 VPWR VGND sg13g2_decap_8
XFILLER_42_133 VPWR VGND sg13g2_decap_8
XFILLER_43_623 VPWR VGND sg13g2_decap_8
XFILLER_11_564 VPWR VGND sg13g2_decap_8
XFILLER_23_391 VPWR VGND sg13g2_decap_8
Xclkbuf_5_19__f_clk clknet_5_19__leaf_clk clknet_4_9_0_clk VPWR VGND sg13g2_buf_16
XFILLER_7_546 VPWR VGND sg13g2_decap_8
XFILLER_2_284 VPWR VGND sg13g2_decap_8
XFILLER_18_185 VPWR VGND sg13g2_decap_8
XFILLER_33_100 VPWR VGND sg13g2_decap_8
XFILLER_46_483 VPWR VGND sg13g2_decap_8
X_1051_ daisychain\[59\] net18 VPWR VGND sg13g2_buf_1
XFILLER_14_391 VPWR VGND sg13g2_decap_8
XFILLER_21_339 VPWR VGND sg13g2_decap_8
XFILLER_33_177 VPWR VGND sg13g2_decap_8
X_0904_ net101 VGND VPWR _0064_ daisychain\[0\] clknet_5_24__leaf_clk sg13g2_dfrbpq_1
X_0835_ VPWR _0217_ daisychain\[24\] VGND sg13g2_inv_1
X_0766_ _0397_ VPWR _0174_ VGND net96 _0005_ sg13g2_o21ai_1
X_0697_ VGND VPWR net32 daisychain\[57\] _0434_ net33 sg13g2_a21oi_1
XFILLER_29_439 VPWR VGND sg13g2_decap_8
XFILLER_24_100 VPWR VGND sg13g2_decap_8
XFILLER_24_177 VPWR VGND sg13g2_decap_8
XFILLER_25_634 VPWR VGND sg13g2_decap_8
XFILLER_21_11 VPWR VGND sg13g2_decap_8
XFILLER_0_700 VPWR VGND sg13g2_decap_8
XFILLER_21_66 VPWR VGND sg13g2_decap_8
XFILLER_46_63 VPWR VGND sg13g2_decap_8
XFILLER_47_203 VPWR VGND sg13g2_decap_8
XFILLER_15_133 VPWR VGND sg13g2_decap_8
XFILLER_30_158 VPWR VGND sg13g2_decap_8
XFILLER_43_420 VPWR VGND sg13g2_decap_8
XFILLER_43_497 VPWR VGND sg13g2_decap_8
XFILLER_11_361 VPWR VGND sg13g2_decap_8
X_0620_ _0232_ net75 _0375_ _0376_ VPWR VGND sg13g2_a21o_1
X_0551_ net89 VPWR _0324_ VGND net67 state\[22\] sg13g2_o21ai_1
XFILLER_7_35 VPWR VGND sg13g2_decap_8
XFILLER_7_343 VPWR VGND sg13g2_decap_8
XFILLER_23_4 VPWR VGND sg13g2_decap_4
XFILLER_38_203 VPWR VGND sg13g2_decap_8
XFILLER_3_571 VPWR VGND sg13g2_decap_8
X_0482_ _0068_ _0271_ _0272_ net36 _0197_ VPWR VGND sg13g2_a22oi_1
XFILLER_22_615 VPWR VGND sg13g2_decap_8
XFILLER_34_420 VPWR VGND sg13g2_decap_8
XFILLER_46_280 VPWR VGND sg13g2_decap_8
XFILLER_21_136 VPWR VGND sg13g2_decap_8
XFILLER_34_497 VPWR VGND sg13g2_decap_8
X_0818_ VPWR _0039_ state\[16\] VGND sg13g2_inv_1
X_0749_ _0346_ VPWR _0157_ VGND net84 _0053_ sg13g2_o21ai_1
XFILLER_17_409 VPWR VGND sg13g2_decap_8
XFILLER_29_236 VPWR VGND sg13g2_decap_8
XFILLER_44_217 VPWR VGND sg13g2_decap_8
XFILLER_12_158 VPWR VGND sg13g2_decap_8
XFILLER_13_637 VPWR VGND sg13g2_decap_8
XFILLER_16_77 VPWR VGND sg13g2_decap_8
XFILLER_25_431 VPWR VGND sg13g2_decap_8
XFILLER_40_434 VPWR VGND sg13g2_decap_8
XFILLER_9_608 VPWR VGND sg13g2_fill_1
XFILLER_32_32 VPWR VGND sg13g2_decap_8
XFILLER_40_489 VPWR VGND sg13g2_decap_4
XFILLER_0_574 VPWR VGND sg13g2_decap_8
XFILLER_4_368 VPWR VGND sg13g2_decap_8
XFILLER_16_420 VPWR VGND sg13g2_decap_8
XFILLER_29_770 VPWR VGND sg13g2_decap_8
XFILLER_29_781 VPWR VGND sg13g2_fill_2
XFILLER_36_718 VPWR VGND sg13g2_fill_2
XFILLER_48_567 VPWR VGND sg13g2_decap_8
XFILLER_16_497 VPWR VGND sg13g2_decap_8
XFILLER_31_445 VPWR VGND sg13g2_decap_8
XFILLER_43_294 VPWR VGND sg13g2_decap_8
XFILLER_7_140 VPWR VGND sg13g2_decap_8
X_0603_ net94 VPWR _0363_ VGND net69 state\[35\] sg13g2_o21ai_1
X_0534_ _0081_ _0310_ _0311_ net44 _0210_ VPWR VGND sg13g2_a22oi_1
XFILLER_26_217 VPWR VGND sg13g2_decap_8
XFILLER_27_729 VPWR VGND sg13g2_decap_4
X_0465_ VGND VPWR _0192_ net2 _0260_ net55 sg13g2_a21oi_1
XFILLER_22_412 VPWR VGND sg13g2_decap_8
XFILLER_34_294 VPWR VGND sg13g2_decap_8
X_1017_ net120 VGND VPWR _0177_ state\[49\] clknet_5_13__leaf_clk sg13g2_dfrbpq_1
Xheichips25_pudding_130 VPWR VGND uio_oe[7] sg13g2_tiehi
XFILLER_22_489 VPWR VGND sg13g2_decap_8
XFILLER_17_206 VPWR VGND sg13g2_decap_8
XFILLER_27_76 VPWR VGND sg13g2_decap_8
XFILLER_45_504 VPWR VGND sg13g2_decap_8
XFILLER_13_412 VPWR VGND sg13g2_decap_8
XFILLER_13_489 VPWR VGND sg13g2_decap_8
XFILLER_26_795 VPWR VGND sg13g2_fill_2
XFILLER_40_231 VPWR VGND sg13g2_decap_8
XFILLER_41_732 VPWR VGND sg13g2_decap_8
XFILLER_43_42 VPWR VGND sg13g2_decap_8
XFILLER_9_438 VPWR VGND sg13g2_decap_8
XFILLER_5_688 VPWR VGND sg13g2_fill_2
XFILLER_5_677 VPWR VGND sg13g2_decap_8
XFILLER_4_25 VPWR VGND sg13g2_decap_8
XFILLER_4_165 VPWR VGND sg13g2_decap_8
XFILLER_0_371 VPWR VGND sg13g2_decap_8
XFILLER_48_364 VPWR VGND sg13g2_decap_8
XFILLER_16_294 VPWR VGND sg13g2_decap_8
XFILLER_17_740 VPWR VGND sg13g2_fill_1
XFILLER_23_209 VPWR VGND sg13g2_decap_8
XFILLER_31_242 VPWR VGND sg13g2_decap_8
XFILLER_44_581 VPWR VGND sg13g2_decap_8
X_0517_ VGND VPWR net25 daisychain\[12\] _0299_ net41 sg13g2_a21oi_1
XFILLER_14_209 VPWR VGND sg13g2_decap_8
XFILLER_27_559 VPWR VGND sg13g2_decap_8
XFILLER_39_364 VPWR VGND sg13g2_decap_8
XFILLER_42_518 VPWR VGND sg13g2_decap_8
XFILLER_10_459 VPWR VGND sg13g2_decap_8
XFILLER_13_34 VPWR VGND sg13g2_decap_8
XFILLER_22_286 VPWR VGND sg13g2_decap_8
XFILLER_23_787 VPWR VGND sg13g2_fill_2
Xfanout24 net27 net24 VPWR VGND sg13g2_buf_1
Xfanout79 net5 net79 VPWR VGND sg13g2_buf_1
Xfanout68 net78 net68 VPWR VGND sg13g2_buf_1
Xfanout57 net58 net57 VPWR VGND sg13g2_buf_1
Xfanout46 net49 net46 VPWR VGND sg13g2_buf_1
Xfanout35 _0259_ net35 VPWR VGND sg13g2_buf_1
XFILLER_18_526 VPWR VGND sg13g2_decap_8
XFILLER_1_168 VPWR VGND sg13g2_decap_8
XFILLER_2_669 VPWR VGND sg13g2_decap_8
XFILLER_38_42 VPWR VGND sg13g2_decap_8
XFILLER_45_301 VPWR VGND sg13g2_decap_8
XFILLER_26_581 VPWR VGND sg13g2_decap_8
XFILLER_45_378 VPWR VGND sg13g2_decap_8
XFILLER_13_286 VPWR VGND sg13g2_decap_8
XFILLER_41_595 VPWR VGND sg13g2_decap_8
XFILLER_9_235 VPWR VGND sg13g2_decap_8
Xdigitalen.g\[1\].u.inv1 VPWR digitalen.g\[1\].u.OUTN net6 VGND sg13g2_inv_1
XFILLER_5_452 VPWR VGND sg13g2_decap_8
XFILLER_36_323 VPWR VGND sg13g2_decap_8
XFILLER_48_161 VPWR VGND sg13g2_decap_8
XFILLER_49_662 VPWR VGND sg13g2_decap_8
XFILLER_17_570 VPWR VGND sg13g2_decap_8
X_0997_ net105 VGND VPWR _0157_ state\[29\] clknet_5_25__leaf_clk sg13g2_dfrbpq_1
XFILLER_39_161 VPWR VGND sg13g2_decap_8
XFILLER_15_518 VPWR VGND sg13g2_decap_8
XFILLER_24_11 VPWR VGND sg13g2_decap_8
XFILLER_24_22 VPWR VGND sg13g2_fill_2
XFILLER_27_356 VPWR VGND sg13g2_decap_8
XFILLER_42_315 VPWR VGND sg13g2_decap_8
XFILLER_10_256 VPWR VGND sg13g2_decap_8
XFILLER_23_573 VPWR VGND sg13g2_decap_8
XFILLER_24_44 VPWR VGND sg13g2_decap_8
XFILLER_40_21 VPWR VGND sg13g2_decap_8
XFILLER_6_249 VPWR VGND sg13g2_decap_8
XFILLER_2_466 VPWR VGND sg13g2_decap_8
XFILLER_40_98 VPWR VGND sg13g2_decap_8
XFILLER_18_367 VPWR VGND sg13g2_decap_8
XFILLER_46_665 VPWR VGND sg13g2_decap_8
XFILLER_49_74 VPWR VGND sg13g2_decap_8
XFILLER_14_573 VPWR VGND sg13g2_decap_8
XFILLER_33_359 VPWR VGND sg13g2_decap_8
XFILLER_41_392 VPWR VGND sg13g2_decap_8
XFILLER_45_175 VPWR VGND sg13g2_decap_8
X_0920_ net109 VGND VPWR _0080_ daisychain\[16\] clknet_5_30__leaf_clk sg13g2_dfrbpq_1
X_0851_ VPWR _0225_ daisychain\[32\] VGND sg13g2_inv_1
X_0782_ _0451_ net32 state\[62\] VPWR VGND sg13g2_nand2_1
XFILLER_24_359 VPWR VGND sg13g2_decap_8
XFILLER_36_120 VPWR VGND sg13g2_decap_8
XFILLER_36_197 VPWR VGND sg13g2_decap_8
XFILLER_37_632 VPWR VGND sg13g2_decap_8
XFILLER_37_687 VPWR VGND sg13g2_fill_2
Xinput3 ui_in[1] net3 VPWR VGND sg13g2_buf_1
XFILLER_10_46 VPWR VGND sg13g2_decap_8
XFILLER_19_99 VPWR VGND sg13g2_decap_8
XFILLER_27_153 VPWR VGND sg13g2_decap_8
XFILLER_28_621 VPWR VGND sg13g2_decap_8
XFILLER_43_602 VPWR VGND sg13g2_decap_8
XFILLER_15_315 VPWR VGND sg13g2_decap_8
XFILLER_23_370 VPWR VGND sg13g2_decap_8
XFILLER_35_76 VPWR VGND sg13g2_decap_8
XFILLER_42_112 VPWR VGND sg13g2_decap_8
XFILLER_42_189 VPWR VGND sg13g2_decap_8
XFILLER_11_543 VPWR VGND sg13g2_decap_8
XFILLER_7_525 VPWR VGND sg13g2_decap_8
XFILLER_2_263 VPWR VGND sg13g2_decap_8
XFILLER_3_753 VPWR VGND sg13g2_fill_1
XFILLER_3_786 VPWR VGND sg13g2_decap_4
XFILLER_18_164 VPWR VGND sg13g2_decap_8
XFILLER_19_643 VPWR VGND sg13g2_fill_1
XFILLER_19_665 VPWR VGND sg13g2_decap_8
XFILLER_46_462 VPWR VGND sg13g2_decap_8
X_1050_ daisychain\[58\] net17 VPWR VGND sg13g2_buf_1
XFILLER_14_370 VPWR VGND sg13g2_decap_8
XFILLER_21_318 VPWR VGND sg13g2_decap_8
XFILLER_33_156 VPWR VGND sg13g2_decap_8
X_0903_ VPWR _0251_ daisychain\[58\] VGND sg13g2_inv_1
X_0834_ VPWR _0048_ state\[24\] VGND sg13g2_inv_1
XFILLER_44_0 VPWR VGND sg13g2_decap_8
X_0765_ _0394_ VPWR _0173_ VGND net96 _0004_ sg13g2_o21ai_1
X_0696_ _0251_ net56 _0432_ _0433_ VPWR VGND sg13g2_a21o_1
XFILLER_29_418 VPWR VGND sg13g2_decap_8
Xclkbuf_5_25__f_clk clknet_5_25__leaf_clk clknet_4_12_0_clk VPWR VGND sg13g2_buf_16
XFILLER_24_156 VPWR VGND sg13g2_decap_8
XFILLER_25_613 VPWR VGND sg13g2_decap_8
XFILLER_37_484 VPWR VGND sg13g2_decap_8
XFILLER_20_384 VPWR VGND sg13g2_decap_8
XFILLER_21_45 VPWR VGND sg13g2_decap_8
XFILLER_0_778 VPWR VGND sg13g2_decap_4
XFILLER_0_789 VPWR VGND sg13g2_fill_1
XFILLER_15_112 VPWR VGND sg13g2_decap_8
XFILLER_16_602 VPWR VGND sg13g2_fill_2
XFILLER_28_495 VPWR VGND sg13g2_decap_8
XFILLER_46_42 VPWR VGND sg13g2_decap_8
XFILLER_47_259 VPWR VGND sg13g2_decap_8
XFILLER_48_749 VPWR VGND sg13g2_decap_8
XFILLER_11_340 VPWR VGND sg13g2_decap_8
XFILLER_15_189 VPWR VGND sg13g2_decap_8
XFILLER_16_679 VPWR VGND sg13g2_decap_4
XFILLER_30_137 VPWR VGND sg13g2_decap_8
XFILLER_43_476 VPWR VGND sg13g2_decap_8
XFILLER_7_322 VPWR VGND sg13g2_decap_8
XFILLER_7_14 VPWR VGND sg13g2_decap_8
XFILLER_3_550 VPWR VGND sg13g2_decap_8
X_0550_ _0085_ _0322_ _0323_ net43 _0214_ VPWR VGND sg13g2_a22oi_1
XFILLER_7_399 VPWR VGND sg13g2_decap_8
XFILLER_38_259 VPWR VGND sg13g2_decap_8
X_0481_ VGND VPWR net23 daisychain\[3\] _0272_ net36 sg13g2_a21oi_1
XFILLER_19_484 VPWR VGND sg13g2_decap_8
XFILLER_21_115 VPWR VGND sg13g2_decap_8
XFILLER_34_476 VPWR VGND sg13g2_decap_8
XFILLER_30_682 VPWR VGND sg13g2_decap_8
X_0817_ VPWR _0208_ daisychain\[15\] VGND sg13g2_inv_1
X_0748_ _0343_ VPWR _0156_ VGND net81 _0052_ sg13g2_o21ai_1
X_0679_ net93 VPWR _0420_ VGND net71 state\[54\] sg13g2_o21ai_1
XFILLER_25_410 VPWR VGND sg13g2_decap_8
XFILLER_29_215 VPWR VGND sg13g2_decap_8
XFILLER_37_292 VPWR VGND sg13g2_decap_8
XFILLER_12_137 VPWR VGND sg13g2_decap_8
XFILLER_16_56 VPWR VGND sg13g2_decap_8
XFILLER_25_487 VPWR VGND sg13g2_decap_8
XFILLER_32_11 VPWR VGND sg13g2_decap_8
XFILLER_40_413 VPWR VGND sg13g2_decap_8
XFILLER_8_119 VPWR VGND sg13g2_decap_8
XFILLER_20_181 VPWR VGND sg13g2_decap_8
XFILLER_32_88 VPWR VGND sg13g2_decap_8
XFILLER_4_347 VPWR VGND sg13g2_decap_8
XFILLER_0_553 VPWR VGND sg13g2_decap_8
XFILLER_48_546 VPWR VGND sg13g2_decap_8
XFILLER_16_476 VPWR VGND sg13g2_decap_8
XFILLER_28_292 VPWR VGND sg13g2_decap_8
XFILLER_31_424 VPWR VGND sg13g2_decap_8
XFILLER_43_273 VPWR VGND sg13g2_decap_8
X_0602_ _0098_ _0361_ _0362_ net46 _0227_ VPWR VGND sg13g2_a22oi_1
X_0533_ VGND VPWR net26 daisychain\[16\] _0311_ net44 sg13g2_a21oi_1
X_0464_ net80 net3 _0259_ VPWR VGND sg13g2_nor2_1
XFILLER_7_196 VPWR VGND sg13g2_decap_8
XFILLER_19_281 VPWR VGND sg13g2_decap_8
XFILLER_22_468 VPWR VGND sg13g2_decap_8
XFILLER_34_273 VPWR VGND sg13g2_decap_8
X_1016_ net120 VGND VPWR _0176_ state\[48\] clknet_5_15__leaf_clk sg13g2_dfrbpq_1
XFILLER_25_284 VPWR VGND sg13g2_decap_8
XFILLER_27_55 VPWR VGND sg13g2_decap_8
XFILLER_40_210 VPWR VGND sg13g2_decap_8
XFILLER_43_21 VPWR VGND sg13g2_decap_8
XFILLER_13_468 VPWR VGND sg13g2_decap_8
XFILLER_40_287 VPWR VGND sg13g2_decap_8
XFILLER_43_98 VPWR VGND sg13g2_decap_8
XFILLER_9_417 VPWR VGND sg13g2_decap_8
XFILLER_5_634 VPWR VGND sg13g2_decap_4
XFILLER_4_144 VPWR VGND sg13g2_decap_8
XFILLER_0_350 VPWR VGND sg13g2_decap_8
XFILLER_36_549 VPWR VGND sg13g2_decap_8
XFILLER_48_343 VPWR VGND sg13g2_decap_8
XFILLER_16_273 VPWR VGND sg13g2_decap_8
XFILLER_31_221 VPWR VGND sg13g2_decap_8
XFILLER_44_560 VPWR VGND sg13g2_decap_8
XFILLER_31_298 VPWR VGND sg13g2_decap_8
XFILLER_8_483 VPWR VGND sg13g2_decap_8
XFILLER_39_343 VPWR VGND sg13g2_decap_8
X_0516_ _0206_ net65 _0297_ _0298_ VPWR VGND sg13g2_a21o_1
XFILLER_27_538 VPWR VGND sg13g2_decap_8
XFILLER_10_438 VPWR VGND sg13g2_decap_8
XFILLER_13_13 VPWR VGND sg13g2_decap_8
XFILLER_22_265 VPWR VGND sg13g2_decap_8
Xfanout25 net26 net25 VPWR VGND sg13g2_buf_1
Xfanout69 net72 net69 VPWR VGND sg13g2_buf_1
Xfanout58 net79 net58 VPWR VGND sg13g2_buf_1
Xfanout47 net49 net47 VPWR VGND sg13g2_buf_1
Xfanout36 net39 net36 VPWR VGND sg13g2_buf_1
XFILLER_1_147 VPWR VGND sg13g2_decap_8
XFILLER_2_648 VPWR VGND sg13g2_decap_8
XFILLER_38_21 VPWR VGND sg13g2_fill_1
XFILLER_38_98 VPWR VGND sg13g2_decap_8
XFILLER_13_265 VPWR VGND sg13g2_decap_8
XFILLER_26_560 VPWR VGND sg13g2_decap_8
XFILLER_41_574 VPWR VGND sg13g2_decap_8
XFILLER_45_357 VPWR VGND sg13g2_decap_8
XFILLER_9_214 VPWR VGND sg13g2_decap_8
Xdigitalen.g\[1\].u.inv2 VPWR digitalen.g\[1\].u.OUTP digitalen.g\[1\].u.OUTN VGND
+ sg13g2_inv_1
XFILLER_5_431 VPWR VGND sg13g2_decap_8
Xclkbuf_5_6__f_clk clknet_5_6__leaf_clk clknet_4_3_0_clk VPWR VGND sg13g2_buf_16
XFILLER_49_641 VPWR VGND sg13g2_decap_8
XFILLER_48_7 VPWR VGND sg13g2_decap_8
XFILLER_36_302 VPWR VGND sg13g2_decap_8
XFILLER_48_140 VPWR VGND sg13g2_decap_8
XFILLER_32_585 VPWR VGND sg13g2_decap_8
X_0996_ net106 VGND VPWR _0156_ state\[28\] clknet_5_27__leaf_clk sg13g2_dfrbpq_1
XFILLER_8_280 VPWR VGND sg13g2_decap_8
XFILLER_27_335 VPWR VGND sg13g2_decap_8
XFILLER_39_140 VPWR VGND sg13g2_decap_8
XFILLER_23_552 VPWR VGND sg13g2_decap_8
XFILLER_10_235 VPWR VGND sg13g2_decap_8
XFILLER_40_77 VPWR VGND sg13g2_decap_8
XFILLER_6_228 VPWR VGND sg13g2_decap_8
XFILLER_2_445 VPWR VGND sg13g2_decap_8
XFILLER_49_53 VPWR VGND sg13g2_decap_8
XFILLER_18_346 VPWR VGND sg13g2_decap_8
XFILLER_19_803 VPWR VGND sg13g2_fill_2
XFILLER_1_49 VPWR VGND sg13g2_decap_8
XFILLER_45_154 VPWR VGND sg13g2_decap_8
XFILLER_46_644 VPWR VGND sg13g2_decap_8
XFILLER_14_552 VPWR VGND sg13g2_decap_8
XFILLER_33_338 VPWR VGND sg13g2_decap_8
XFILLER_41_371 VPWR VGND sg13g2_decap_8
X_0850_ VPWR _0000_ state\[32\] VGND sg13g2_inv_1
X_0781_ _0442_ VPWR _0189_ VGND net100 _0021_ sg13g2_o21ai_1
XFILLER_6_795 VPWR VGND sg13g2_fill_2
Xinput4 ui_in[2] net4 VPWR VGND sg13g2_buf_1
XFILLER_24_338 VPWR VGND sg13g2_decap_8
XFILLER_36_176 VPWR VGND sg13g2_decap_8
XFILLER_37_666 VPWR VGND sg13g2_fill_1
XFILLER_20_522 VPWR VGND sg13g2_decap_8
XFILLER_20_533 VPWR VGND sg13g2_fill_2
XFILLER_32_382 VPWR VGND sg13g2_decap_8
X_0979_ net107 VGND VPWR _0139_ state\[11\] clknet_5_16__leaf_clk sg13g2_dfrbpq_1
XFILLER_10_25 VPWR VGND sg13g2_decap_8
XFILLER_19_78 VPWR VGND sg13g2_decap_8
XFILLER_27_132 VPWR VGND sg13g2_decap_8
XFILLER_28_600 VPWR VGND sg13g2_decap_8
XFILLER_28_699 VPWR VGND sg13g2_fill_1
XFILLER_11_522 VPWR VGND sg13g2_decap_8
XFILLER_30_319 VPWR VGND sg13g2_decap_8
XFILLER_35_55 VPWR VGND sg13g2_decap_8
XFILLER_42_168 VPWR VGND sg13g2_decap_8
XFILLER_43_658 VPWR VGND sg13g2_decap_8
XFILLER_7_504 VPWR VGND sg13g2_decap_8
XFILLER_11_599 VPWR VGND sg13g2_fill_2
XFILLER_3_743 VPWR VGND sg13g2_fill_1
XFILLER_18_8 VPWR VGND sg13g2_fill_1
XFILLER_2_242 VPWR VGND sg13g2_decap_8
XFILLER_18_143 VPWR VGND sg13g2_decap_8
XFILLER_33_135 VPWR VGND sg13g2_decap_8
XFILLER_46_441 VPWR VGND sg13g2_decap_8
X_0902_ VPWR _0018_ state\[58\] VGND sg13g2_inv_1
X_0833_ VPWR _0216_ daisychain\[23\] VGND sg13g2_inv_1
XFILLER_37_0 VPWR VGND sg13g2_decap_8
X_0764_ _0391_ VPWR _0172_ VGND net95 _0003_ sg13g2_o21ai_1
X_0695_ net80 VPWR _0432_ VGND net56 state\[58\] sg13g2_o21ai_1
XFILLER_6_592 VPWR VGND sg13g2_decap_8
XFILLER_2_81 VPWR VGND sg13g2_decap_8
XFILLER_37_463 VPWR VGND sg13g2_decap_8
XFILLER_12_319 VPWR VGND sg13g2_decap_8
XFILLER_24_135 VPWR VGND sg13g2_decap_8
XFILLER_33_680 VPWR VGND sg13g2_decap_8
XFILLER_33_691 VPWR VGND sg13g2_fill_1
XFILLER_37_496 VPWR VGND sg13g2_decap_8
XFILLER_20_363 VPWR VGND sg13g2_decap_8
XFILLER_21_24 VPWR VGND sg13g2_decap_8
XFILLER_4_529 VPWR VGND sg13g2_decap_8
XFILLER_0_724 VPWR VGND sg13g2_decap_4
XFILLER_0_746 VPWR VGND sg13g2_decap_8
XFILLER_48_728 VPWR VGND sg13g2_decap_8
XFILLER_15_168 VPWR VGND sg13g2_decap_8
XFILLER_28_474 VPWR VGND sg13g2_decap_8
XFILLER_43_455 VPWR VGND sg13g2_decap_8
XFILLER_46_21 VPWR VGND sg13g2_decap_8
XFILLER_46_98 VPWR VGND sg13g2_decap_8
XFILLER_47_238 VPWR VGND sg13g2_decap_8
XFILLER_11_396 VPWR VGND sg13g2_decap_8
XFILLER_30_116 VPWR VGND sg13g2_decap_8
XFILLER_7_301 VPWR VGND sg13g2_decap_8
Xclkbuf_5_31__f_clk clknet_5_31__leaf_clk clknet_4_15_0_clk VPWR VGND sg13g2_buf_16
X_0480_ _0197_ net59 _0270_ _0271_ VPWR VGND sg13g2_a21o_1
XFILLER_7_378 VPWR VGND sg13g2_decap_8
XFILLER_19_463 VPWR VGND sg13g2_decap_8
XFILLER_38_238 VPWR VGND sg13g2_decap_8
XFILLER_47_772 VPWR VGND sg13g2_decap_8
XFILLER_34_455 VPWR VGND sg13g2_decap_8
X_0816_ VPWR _0038_ state\[15\] VGND sg13g2_inv_1
X_0747_ _0340_ VPWR _0155_ VGND net84 _0051_ sg13g2_o21ai_1
X_0678_ _0117_ _0418_ _0419_ net53 _0246_ VPWR VGND sg13g2_a22oi_1
XFILLER_16_35 VPWR VGND sg13g2_decap_8
XFILLER_25_466 VPWR VGND sg13g2_decap_8
XFILLER_37_271 VPWR VGND sg13g2_decap_8
XFILLER_12_116 VPWR VGND sg13g2_decap_8
XFILLER_20_160 VPWR VGND sg13g2_decap_8
XFILLER_21_683 VPWR VGND sg13g2_decap_4
XFILLER_32_67 VPWR VGND sg13g2_decap_8
XFILLER_40_469 VPWR VGND sg13g2_decap_8
XFILLER_4_326 VPWR VGND sg13g2_decap_8
XFILLER_0_532 VPWR VGND sg13g2_decap_8
XFILLER_48_525 VPWR VGND sg13g2_decap_8
XFILLER_16_455 VPWR VGND sg13g2_decap_8
XFILLER_28_271 VPWR VGND sg13g2_decap_8
XFILLER_31_403 VPWR VGND sg13g2_decap_8
XFILLER_43_252 VPWR VGND sg13g2_decap_8
XFILLER_11_193 VPWR VGND sg13g2_decap_8
X_0601_ VGND VPWR net28 daisychain\[33\] _0362_ net46 sg13g2_a21oi_1
XFILLER_7_175 VPWR VGND sg13g2_decap_8
XFILLER_39_514 VPWR VGND sg13g2_decap_8
X_0532_ _0210_ net67 _0309_ _0310_ VPWR VGND sg13g2_a21o_1
X_0463_ net79 _0193_ _0257_ _0258_ VPWR VGND sg13g2_a21o_1
XFILLER_19_260 VPWR VGND sg13g2_decap_8
XFILLER_34_252 VPWR VGND sg13g2_decap_8
X_1015_ net118 VGND VPWR _0175_ state\[47\] clknet_5_7__leaf_clk sg13g2_dfrbpq_1
XFILLER_22_447 VPWR VGND sg13g2_decap_8
XFILLER_30_480 VPWR VGND sg13g2_decap_8
XFILLER_1_329 VPWR VGND sg13g2_decap_8
XFILLER_8_91 VPWR VGND sg13g2_decap_8
XFILLER_27_34 VPWR VGND sg13g2_decap_8
XFILLER_13_447 VPWR VGND sg13g2_decap_8
XFILLER_25_263 VPWR VGND sg13g2_decap_8
XFILLER_45_539 VPWR VGND sg13g2_decap_8
XFILLER_40_266 VPWR VGND sg13g2_decap_8
XFILLER_43_77 VPWR VGND sg13g2_decap_8
XFILLER_5_646 VPWR VGND sg13g2_decap_8
XFILLER_5_613 VPWR VGND sg13g2_decap_8
XFILLER_4_123 VPWR VGND sg13g2_decap_8
XFILLER_17_731 VPWR VGND sg13g2_decap_8
XFILLER_36_528 VPWR VGND sg13g2_decap_8
XFILLER_48_322 VPWR VGND sg13g2_decap_8
XFILLER_48_399 VPWR VGND sg13g2_decap_8
XFILLER_12_480 VPWR VGND sg13g2_decap_8
XFILLER_16_252 VPWR VGND sg13g2_decap_8
XFILLER_31_200 VPWR VGND sg13g2_decap_8
XFILLER_31_277 VPWR VGND sg13g2_decap_8
XFILLER_8_462 VPWR VGND sg13g2_decap_8
XFILLER_27_517 VPWR VGND sg13g2_decap_8
XFILLER_39_322 VPWR VGND sg13g2_decap_8
X_0515_ net88 VPWR _0297_ VGND net65 state\[13\] sg13g2_o21ai_1
XFILLER_35_594 VPWR VGND sg13g2_decap_8
XFILLER_39_399 VPWR VGND sg13g2_decap_8
Xfanout26 net27 net26 VPWR VGND sg13g2_buf_1
Xfanout37 net39 net37 VPWR VGND sg13g2_buf_1
XFILLER_10_417 VPWR VGND sg13g2_decap_8
XFILLER_13_69 VPWR VGND sg13g2_decap_8
XFILLER_22_244 VPWR VGND sg13g2_decap_8
Xfanout59 net63 net59 VPWR VGND sg13g2_buf_1
Xfanout48 net49 net48 VPWR VGND sg13g2_buf_1
XFILLER_1_126 VPWR VGND sg13g2_decap_8
XFILLER_2_627 VPWR VGND sg13g2_decap_8
XFILLER_38_77 VPWR VGND sg13g2_decap_8
XFILLER_45_336 VPWR VGND sg13g2_decap_8
XFILLER_13_244 VPWR VGND sg13g2_decap_8
XFILLER_41_553 VPWR VGND sg13g2_decap_8
XFILLER_5_487 VPWR VGND sg13g2_decap_8
XFILLER_5_410 VPWR VGND sg13g2_decap_8
XFILLER_1_693 VPWR VGND sg13g2_decap_8
XFILLER_49_620 VPWR VGND sg13g2_decap_8
XFILLER_36_358 VPWR VGND sg13g2_decap_8
XFILLER_48_196 VPWR VGND sg13g2_decap_8
XFILLER_49_697 VPWR VGND sg13g2_decap_8
XFILLER_32_564 VPWR VGND sg13g2_decap_8
X_0995_ net106 VGND VPWR _0155_ state\[27\] clknet_5_25__leaf_clk sg13g2_dfrbpq_1
XFILLER_5_81 VPWR VGND sg13g2_decap_8
XFILLER_27_314 VPWR VGND sg13g2_decap_8
XFILLER_39_196 VPWR VGND sg13g2_decap_8
XFILLER_10_214 VPWR VGND sg13g2_decap_8
XFILLER_23_531 VPWR VGND sg13g2_decap_8
XFILLER_24_79 VPWR VGND sg13g2_decap_8
XFILLER_35_391 VPWR VGND sg13g2_decap_8
XFILLER_40_56 VPWR VGND sg13g2_decap_8
XFILLER_7_719 VPWR VGND sg13g2_decap_8
XFILLER_7_708 VPWR VGND sg13g2_fill_1
XFILLER_6_207 VPWR VGND sg13g2_decap_8
XFILLER_1_28 VPWR VGND sg13g2_decap_8
XFILLER_2_424 VPWR VGND sg13g2_decap_8
XFILLER_6_4 VPWR VGND sg13g2_decap_8
XFILLER_49_32 VPWR VGND sg13g2_decap_8
XFILLER_14_531 VPWR VGND sg13g2_decap_8
XFILLER_18_325 VPWR VGND sg13g2_decap_8
XFILLER_33_317 VPWR VGND sg13g2_decap_8
XFILLER_45_133 VPWR VGND sg13g2_decap_8
XFILLER_46_623 VPWR VGND sg13g2_decap_8
XFILLER_14_90 VPWR VGND sg13g2_decap_8
XFILLER_41_350 VPWR VGND sg13g2_decap_8
X_0780_ _0439_ VPWR _0188_ VGND net100 _0020_ sg13g2_o21ai_1
XFILLER_5_284 VPWR VGND sg13g2_decap_8
XFILLER_1_490 VPWR VGND sg13g2_decap_8
XFILLER_25_807 VPWR VGND sg13g2_decap_8
Xinput5 ui_in[3] net5 VPWR VGND sg13g2_buf_1
XFILLER_49_494 VPWR VGND sg13g2_decap_8
XFILLER_24_317 VPWR VGND sg13g2_decap_8
XFILLER_32_361 VPWR VGND sg13g2_decap_8
XFILLER_36_155 VPWR VGND sg13g2_decap_8
XFILLER_37_689 VPWR VGND sg13g2_fill_1
XFILLER_20_589 VPWR VGND sg13g2_decap_8
X_0978_ net107 VGND VPWR _0138_ state\[10\] clknet_5_20__leaf_clk sg13g2_dfrbpq_1
XFILLER_19_57 VPWR VGND sg13g2_decap_8
XFILLER_27_111 VPWR VGND sg13g2_decap_8
XFILLER_27_188 VPWR VGND sg13g2_decap_8
XFILLER_28_656 VPWR VGND sg13g2_fill_2
XFILLER_35_34 VPWR VGND sg13g2_decap_8
XFILLER_43_637 VPWR VGND sg13g2_decap_8
XFILLER_11_501 VPWR VGND sg13g2_decap_8
XFILLER_11_578 VPWR VGND sg13g2_fill_2
XFILLER_42_147 VPWR VGND sg13g2_decap_8
XFILLER_2_221 VPWR VGND sg13g2_decap_8
XFILLER_18_122 VPWR VGND sg13g2_decap_8
XFILLER_19_634 VPWR VGND sg13g2_fill_1
XFILLER_2_298 VPWR VGND sg13g2_decap_8
XFILLER_38_409 VPWR VGND sg13g2_decap_8
XFILLER_46_420 VPWR VGND sg13g2_decap_8
XFILLER_18_199 VPWR VGND sg13g2_decap_8
XFILLER_33_114 VPWR VGND sg13g2_decap_8
XFILLER_46_497 VPWR VGND sg13g2_decap_8
X_0901_ VPWR _0250_ daisychain\[57\] VGND sg13g2_inv_1
X_0832_ VPWR _0047_ state\[23\] VGND sg13g2_inv_1
X_0763_ _0388_ VPWR _0171_ VGND net95 _0002_ sg13g2_o21ai_1
XFILLER_6_571 VPWR VGND sg13g2_decap_8
X_0694_ _0121_ _0430_ _0431_ net35 _0250_ VPWR VGND sg13g2_a22oi_1
XFILLER_24_114 VPWR VGND sg13g2_decap_8
XFILLER_25_648 VPWR VGND sg13g2_decap_8
XFILLER_2_60 VPWR VGND sg13g2_decap_8
XFILLER_37_442 VPWR VGND sg13g2_decap_8
XFILLER_49_291 VPWR VGND sg13g2_decap_8
XFILLER_20_342 VPWR VGND sg13g2_decap_8
XFILLER_0_714 VPWR VGND sg13g2_decap_8
XFILLER_4_508 VPWR VGND sg13g2_decap_8
XFILLER_47_217 VPWR VGND sg13g2_decap_8
XFILLER_48_707 VPWR VGND sg13g2_decap_8
XFILLER_15_147 VPWR VGND sg13g2_decap_8
XFILLER_28_453 VPWR VGND sg13g2_decap_8
XFILLER_43_434 VPWR VGND sg13g2_decap_8
XFILLER_46_77 VPWR VGND sg13g2_decap_8
XFILLER_11_375 VPWR VGND sg13g2_decap_8
XFILLER_7_49 VPWR VGND sg13g2_decap_8
XFILLER_7_357 VPWR VGND sg13g2_decap_8
XFILLER_30_8 VPWR VGND sg13g2_fill_2
XFILLER_3_585 VPWR VGND sg13g2_decap_8
Xclkbuf_4_9_0_clk clknet_0_clk clknet_4_9_0_clk VPWR VGND sg13g2_buf_8
XFILLER_19_442 VPWR VGND sg13g2_decap_8
XFILLER_34_434 VPWR VGND sg13g2_decap_8
XFILLER_38_217 VPWR VGND sg13g2_decap_8
XFILLER_39_729 VPWR VGND sg13g2_decap_8
XFILLER_46_294 VPWR VGND sg13g2_decap_8
XFILLER_47_751 VPWR VGND sg13g2_decap_8
X_1031_ net101 VGND VPWR _0191_ state\[63\] clknet_5_26__leaf_clk sg13g2_dfrbpq_1
XFILLER_22_629 VPWR VGND sg13g2_decap_8
X_0815_ VPWR _0207_ daisychain\[14\] VGND sg13g2_inv_1
X_0746_ _0337_ VPWR _0154_ VGND net84 _0050_ sg13g2_o21ai_1
XFILLER_38_740 VPWR VGND sg13g2_fill_1
X_0677_ VGND VPWR net31 daisychain\[52\] _0419_ net52 sg13g2_a21oi_1
XFILLER_25_445 VPWR VGND sg13g2_decap_8
XFILLER_37_250 VPWR VGND sg13g2_decap_8
XFILLER_21_662 VPWR VGND sg13g2_fill_2
XFILLER_32_46 VPWR VGND sg13g2_decap_8
XFILLER_40_448 VPWR VGND sg13g2_decap_8
XFILLER_4_305 VPWR VGND sg13g2_decap_8
XFILLER_0_511 VPWR VGND sg13g2_decap_8
XFILLER_0_588 VPWR VGND sg13g2_decap_8
XFILLER_28_250 VPWR VGND sg13g2_decap_8
XFILLER_35_209 VPWR VGND sg13g2_decap_8
XFILLER_48_504 VPWR VGND sg13g2_decap_8
XFILLER_12_662 VPWR VGND sg13g2_fill_2
XFILLER_16_434 VPWR VGND sg13g2_decap_8
XFILLER_31_459 VPWR VGND sg13g2_decap_8
XFILLER_43_231 VPWR VGND sg13g2_decap_8
XFILLER_11_172 VPWR VGND sg13g2_decap_8
XFILLER_22_90 VPWR VGND sg13g2_decap_8
X_0600_ _0227_ net69 _0360_ _0361_ VPWR VGND sg13g2_a21o_1
X_0531_ net90 VPWR _0309_ VGND net67 state\[17\] sg13g2_o21ai_1
XFILLER_8_699 VPWR VGND sg13g2_fill_2
XFILLER_7_154 VPWR VGND sg13g2_decap_8
XFILLER_21_4 VPWR VGND sg13g2_decap_8
XFILLER_3_382 VPWR VGND sg13g2_decap_8
X_0462_ net81 VPWR _0257_ VGND state\[0\] net79 sg13g2_o21ai_1
XFILLER_22_426 VPWR VGND sg13g2_decap_8
XFILLER_34_231 VPWR VGND sg13g2_decap_8
XFILLER_47_581 VPWR VGND sg13g2_decap_8
X_1014_ net118 VGND VPWR _0174_ state\[46\] clknet_5_7__leaf_clk sg13g2_dfrbpq_1
XFILLER_8_70 VPWR VGND sg13g2_decap_8
XFILLER_1_308 VPWR VGND sg13g2_decap_8
X_0729_ _0286_ VPWR _0137_ VGND net83 _0063_ sg13g2_o21ai_1
XFILLER_45_518 VPWR VGND sg13g2_decap_8
XFILLER_13_426 VPWR VGND sg13g2_decap_8
XFILLER_25_242 VPWR VGND sg13g2_decap_8
XFILLER_40_245 VPWR VGND sg13g2_decap_8
XFILLER_43_56 VPWR VGND sg13g2_decap_8
XFILLER_4_102 VPWR VGND sg13g2_decap_8
XFILLER_0_385 VPWR VGND sg13g2_decap_8
XFILLER_48_301 VPWR VGND sg13g2_decap_8
XFILLER_4_39 VPWR VGND sg13g2_decap_8
XFILLER_4_179 VPWR VGND sg13g2_decap_8
XFILLER_49_802 VPWR VGND sg13g2_decap_8
XFILLER_16_231 VPWR VGND sg13g2_decap_8
XFILLER_32_724 VPWR VGND sg13g2_fill_1
XFILLER_36_507 VPWR VGND sg13g2_decap_8
XFILLER_48_378 VPWR VGND sg13g2_decap_8
XFILLER_31_256 VPWR VGND sg13g2_decap_8
XFILLER_44_595 VPWR VGND sg13g2_decap_8
XFILLER_8_441 VPWR VGND sg13g2_decap_8
X_0514_ _0076_ _0295_ _0296_ net41 _0205_ VPWR VGND sg13g2_a22oi_1
XFILLER_39_301 VPWR VGND sg13g2_decap_8
XFILLER_39_378 VPWR VGND sg13g2_decap_8
XFILLER_22_223 VPWR VGND sg13g2_decap_8
XFILLER_35_573 VPWR VGND sg13g2_decap_8
Xfanout27 _0192_ net27 VPWR VGND sg13g2_buf_1
Xfanout49 net55 net49 VPWR VGND sg13g2_buf_1
Xfanout38 net39 net38 VPWR VGND sg13g2_buf_1
XFILLER_13_48 VPWR VGND sg13g2_decap_8
XFILLER_2_606 VPWR VGND sg13g2_decap_8
XFILLER_31_790 VPWR VGND sg13g2_decap_4
XFILLER_1_105 VPWR VGND sg13g2_decap_8
XFILLER_8_8 VPWR VGND sg13g2_fill_2
XFILLER_49_109 VPWR VGND sg13g2_decap_8
XFILLER_38_56 VPWR VGND sg13g2_decap_8
XFILLER_45_315 VPWR VGND sg13g2_decap_8
XFILLER_13_223 VPWR VGND sg13g2_decap_8
XFILLER_26_595 VPWR VGND sg13g2_decap_8
XFILLER_41_532 VPWR VGND sg13g2_decap_8
XFILLER_9_249 VPWR VGND sg13g2_decap_8
XFILLER_5_466 VPWR VGND sg13g2_decap_8
XFILLER_0_182 VPWR VGND sg13g2_decap_8
XFILLER_1_672 VPWR VGND sg13g2_decap_8
XFILLER_48_175 VPWR VGND sg13g2_decap_8
XFILLER_49_676 VPWR VGND sg13g2_decap_8
XFILLER_17_584 VPWR VGND sg13g2_decap_8
XFILLER_17_595 VPWR VGND sg13g2_fill_2
XFILLER_32_543 VPWR VGND sg13g2_decap_8
XFILLER_36_337 VPWR VGND sg13g2_decap_8
XFILLER_44_392 VPWR VGND sg13g2_decap_8
X_0994_ net105 VGND VPWR _0154_ state\[26\] clknet_5_28__leaf_clk sg13g2_dfrbpq_1
XFILLER_5_60 VPWR VGND sg13g2_decap_8
XFILLER_28_805 VPWR VGND sg13g2_decap_8
XFILLER_39_175 VPWR VGND sg13g2_decap_8
XFILLER_23_510 VPWR VGND sg13g2_decap_8
XFILLER_23_587 VPWR VGND sg13g2_decap_8
XFILLER_24_58 VPWR VGND sg13g2_decap_8
XFILLER_35_370 VPWR VGND sg13g2_decap_8
XFILLER_42_329 VPWR VGND sg13g2_decap_8
XFILLER_2_403 VPWR VGND sg13g2_decap_8
XFILLER_40_35 VPWR VGND sg13g2_decap_8
XFILLER_49_11 VPWR VGND sg13g2_decap_8
XFILLER_18_304 VPWR VGND sg13g2_decap_8
XFILLER_19_805 VPWR VGND sg13g2_fill_1
XFILLER_19_816 VPWR VGND sg13g2_decap_8
XFILLER_46_602 VPWR VGND sg13g2_decap_8
XFILLER_49_88 VPWR VGND sg13g2_decap_8
XFILLER_14_510 VPWR VGND sg13g2_decap_8
XFILLER_26_392 VPWR VGND sg13g2_decap_8
XFILLER_45_112 VPWR VGND sg13g2_decap_8
XFILLER_45_189 VPWR VGND sg13g2_decap_8
XFILLER_46_679 VPWR VGND sg13g2_decap_8
XFILLER_14_587 VPWR VGND sg13g2_decap_8
Xclkbuf_5_14__f_clk clknet_5_14__leaf_clk clknet_4_7_0_clk VPWR VGND sg13g2_buf_16
Xwires dac0/VcascP[0] dac0/VcascP[1] dac0/Iout wires/VDDA[0] wires/VDDA[1] dac0/VbiasP[1]
+ dac0/VbiasP[0] dac1/VcascP[0] dac1/VcascP[1] dac1/Iout wires/VDDA[2] wires/VDDA[3]
+ dac1/VbiasP[1] dac1/VbiasP[0] i_in i_out analog_wires
XFILLER_5_263 VPWR VGND sg13g2_decap_8
XFILLER_36_134 VPWR VGND sg13g2_decap_8
XFILLER_37_624 VPWR VGND sg13g2_fill_1
Xinput6 ui_in[4] net6 VPWR VGND sg13g2_buf_1
XFILLER_49_473 VPWR VGND sg13g2_decap_8
XFILLER_17_381 VPWR VGND sg13g2_decap_8
XFILLER_32_340 VPWR VGND sg13g2_decap_8
X_0977_ net107 VGND VPWR _0137_ state\[9\] clknet_5_20__leaf_clk sg13g2_dfrbpq_1
XFILLER_19_36 VPWR VGND sg13g2_decap_8
XFILLER_15_329 VPWR VGND sg13g2_decap_8
XFILLER_27_167 VPWR VGND sg13g2_decap_8
XFILLER_28_635 VPWR VGND sg13g2_decap_8
XFILLER_35_13 VPWR VGND sg13g2_decap_8
XFILLER_42_126 VPWR VGND sg13g2_decap_8
XFILLER_43_616 VPWR VGND sg13g2_decap_8
XFILLER_11_557 VPWR VGND sg13g2_decap_8
XFILLER_23_384 VPWR VGND sg13g2_decap_8
XFILLER_7_539 VPWR VGND sg13g2_decap_8
XFILLER_2_200 VPWR VGND sg13g2_decap_8
XFILLER_2_277 VPWR VGND sg13g2_decap_8
XFILLER_18_101 VPWR VGND sg13g2_decap_8
XFILLER_46_476 VPWR VGND sg13g2_decap_8
XFILLER_14_384 VPWR VGND sg13g2_decap_8
XFILLER_18_178 VPWR VGND sg13g2_decap_8
XFILLER_27_690 VPWR VGND sg13g2_decap_8
XFILLER_30_811 VPWR VGND sg13g2_decap_8
XFILLER_30_822 VPWR VGND sg13g2_fill_1
XFILLER_42_682 VPWR VGND sg13g2_fill_2
X_0900_ VPWR _0017_ state\[57\] VGND sg13g2_inv_1
X_0831_ VPWR _0215_ daisychain\[22\] VGND sg13g2_inv_1
X_0762_ _0385_ VPWR _0170_ VGND net95 _0001_ sg13g2_o21ai_1
X_0693_ VGND VPWR net32 daisychain\[56\] _0431_ net35 sg13g2_a21oi_1
XFILLER_6_550 VPWR VGND sg13g2_decap_8
XFILLER_25_627 VPWR VGND sg13g2_decap_8
XFILLER_37_421 VPWR VGND sg13g2_decap_8
XFILLER_49_270 VPWR VGND sg13g2_decap_8
XFILLER_20_321 VPWR VGND sg13g2_decap_8
XFILLER_20_398 VPWR VGND sg13g2_decap_8
XFILLER_21_822 VPWR VGND sg13g2_fill_1
XFILLER_21_59 VPWR VGND sg13g2_decap_8
XFILLER_28_432 VPWR VGND sg13g2_decap_8
XFILLER_46_56 VPWR VGND sg13g2_decap_8
XFILLER_15_126 VPWR VGND sg13g2_decap_8
XFILLER_23_181 VPWR VGND sg13g2_decap_8
XFILLER_24_671 VPWR VGND sg13g2_fill_2
XFILLER_43_413 VPWR VGND sg13g2_decap_8
XFILLER_11_354 VPWR VGND sg13g2_decap_8
XFILLER_7_336 VPWR VGND sg13g2_decap_8
XFILLER_7_28 VPWR VGND sg13g2_decap_8
XFILLER_11_81 VPWR VGND sg13g2_decap_8
XFILLER_23_8 VPWR VGND sg13g2_fill_1
XFILLER_3_564 VPWR VGND sg13g2_decap_8
XFILLER_19_421 VPWR VGND sg13g2_decap_8
XFILLER_19_498 VPWR VGND sg13g2_decap_8
XFILLER_22_608 VPWR VGND sg13g2_decap_8
XFILLER_34_413 VPWR VGND sg13g2_decap_8
XFILLER_46_273 VPWR VGND sg13g2_decap_8
X_1030_ net123 VGND VPWR _0190_ state\[62\] clknet_5_24__leaf_clk sg13g2_dfrbpq_1
XFILLER_14_181 VPWR VGND sg13g2_decap_8
XFILLER_15_660 VPWR VGND sg13g2_decap_4
XFILLER_21_129 VPWR VGND sg13g2_decap_8
XFILLER_30_696 VPWR VGND sg13g2_decap_8
XFILLER_42_490 VPWR VGND sg13g2_decap_8
X_0814_ VPWR _0037_ state\[14\] VGND sg13g2_inv_1
XFILLER_42_0 VPWR VGND sg13g2_decap_8
X_0745_ _0334_ VPWR _0153_ VGND net85 _0049_ sg13g2_o21ai_1
X_0676_ _0246_ net71 _0417_ _0418_ VPWR VGND sg13g2_a21o_1
XFILLER_29_229 VPWR VGND sg13g2_decap_8
XFILLER_25_424 VPWR VGND sg13g2_decap_8
XFILLER_40_427 VPWR VGND sg13g2_decap_8
XFILLER_20_195 VPWR VGND sg13g2_decap_8
XFILLER_32_25 VPWR VGND sg13g2_decap_8
XFILLER_0_567 VPWR VGND sg13g2_decap_8
XFILLER_16_413 VPWR VGND sg13g2_decap_8
XFILLER_29_763 VPWR VGND sg13g2_decap_8
XFILLER_43_210 VPWR VGND sg13g2_decap_8
XFILLER_11_151 VPWR VGND sg13g2_decap_8
XFILLER_12_652 VPWR VGND sg13g2_fill_1
XFILLER_31_438 VPWR VGND sg13g2_decap_8
XFILLER_43_287 VPWR VGND sg13g2_decap_8
XFILLER_3_361 VPWR VGND sg13g2_decap_8
X_0530_ _0080_ _0307_ _0308_ net44 _0209_ VPWR VGND sg13g2_a22oi_1
XFILLER_7_133 VPWR VGND sg13g2_decap_8
XFILLER_14_4 VPWR VGND sg13g2_fill_1
XFILLER_39_549 VPWR VGND sg13g2_decap_4
X_0461_ VPWR _0256_ daisychain\[63\] VGND sg13g2_inv_1
XFILLER_15_490 VPWR VGND sg13g2_decap_8
XFILLER_19_295 VPWR VGND sg13g2_decap_8
XFILLER_22_405 VPWR VGND sg13g2_decap_8
XFILLER_34_210 VPWR VGND sg13g2_decap_8
XFILLER_34_287 VPWR VGND sg13g2_decap_8
XFILLER_47_560 VPWR VGND sg13g2_decap_8
X_1013_ net118 VGND VPWR _0173_ state\[45\] clknet_5_7__leaf_clk sg13g2_dfrbpq_1
X_0728_ _0283_ VPWR _0136_ VGND net87 _0062_ sg13g2_o21ai_1
X_0659_ net98 VPWR _0405_ VGND net76 state\[49\] sg13g2_o21ai_1
XFILLER_25_221 VPWR VGND sg13g2_decap_8
XFILLER_27_69 VPWR VGND sg13g2_decap_8
XFILLER_13_405 VPWR VGND sg13g2_decap_8
XFILLER_25_298 VPWR VGND sg13g2_decap_8
XFILLER_40_224 VPWR VGND sg13g2_decap_8
XFILLER_43_35 VPWR VGND sg13g2_decap_8
Xclkbuf_4_8_0_clk clknet_0_clk clknet_4_8_0_clk VPWR VGND sg13g2_buf_8
XFILLER_21_493 VPWR VGND sg13g2_decap_8
XFILLER_4_18 VPWR VGND sg13g2_decap_8
XFILLER_4_158 VPWR VGND sg13g2_decap_8
XFILLER_0_364 VPWR VGND sg13g2_decap_8
XFILLER_48_357 VPWR VGND sg13g2_decap_8
XFILLER_16_210 VPWR VGND sg13g2_decap_8
XFILLER_16_287 VPWR VGND sg13g2_decap_8
XFILLER_17_80 VPWR VGND sg13g2_decap_8
XFILLER_31_235 VPWR VGND sg13g2_decap_8
XFILLER_44_574 VPWR VGND sg13g2_decap_8
XFILLER_32_769 VPWR VGND sg13g2_fill_1
XFILLER_8_497 VPWR VGND sg13g2_decap_8
XFILLER_8_420 VPWR VGND sg13g2_decap_8
X_0513_ VGND VPWR net25 daisychain\[11\] _0296_ net41 sg13g2_a21oi_1
XFILLER_39_357 VPWR VGND sg13g2_decap_8
XFILLER_13_27 VPWR VGND sg13g2_decap_8
XFILLER_22_202 VPWR VGND sg13g2_decap_8
XFILLER_22_279 VPWR VGND sg13g2_decap_8
XFILLER_35_552 VPWR VGND sg13g2_decap_8
Xfanout28 net31 net28 VPWR VGND sg13g2_buf_1
Xfanout39 net45 net39 VPWR VGND sg13g2_buf_1
XFILLER_38_35 VPWR VGND sg13g2_decap_8
XFILLER_13_202 VPWR VGND sg13g2_decap_8
XFILLER_14_703 VPWR VGND sg13g2_fill_1
XFILLER_18_519 VPWR VGND sg13g2_decap_8
XFILLER_26_574 VPWR VGND sg13g2_decap_8
XFILLER_41_511 VPWR VGND sg13g2_decap_8
XFILLER_13_279 VPWR VGND sg13g2_decap_8
XFILLER_21_290 VPWR VGND sg13g2_decap_8
XFILLER_41_588 VPWR VGND sg13g2_decap_8
XFILLER_9_228 VPWR VGND sg13g2_decap_8
XFILLER_1_651 VPWR VGND sg13g2_decap_8
XFILLER_5_445 VPWR VGND sg13g2_decap_8
XFILLER_0_161 VPWR VGND sg13g2_decap_8
XFILLER_29_390 VPWR VGND sg13g2_decap_8
XFILLER_36_316 VPWR VGND sg13g2_decap_8
XFILLER_48_154 VPWR VGND sg13g2_decap_8
XFILLER_49_655 VPWR VGND sg13g2_decap_8
XFILLER_17_563 VPWR VGND sg13g2_decap_8
XFILLER_32_522 VPWR VGND sg13g2_decap_8
XFILLER_44_371 VPWR VGND sg13g2_decap_8
X_0993_ net105 VGND VPWR _0153_ state\[25\] clknet_5_28__leaf_clk sg13g2_dfrbpq_1
XFILLER_8_294 VPWR VGND sg13g2_decap_8
XFILLER_27_349 VPWR VGND sg13g2_decap_8
XFILLER_39_154 VPWR VGND sg13g2_decap_8
XFILLER_42_308 VPWR VGND sg13g2_decap_8
XFILLER_10_249 VPWR VGND sg13g2_decap_8
XFILLER_11_717 VPWR VGND sg13g2_fill_2
XFILLER_23_566 VPWR VGND sg13g2_decap_8
XFILLER_24_37 VPWR VGND sg13g2_decap_8
XFILLER_40_14 VPWR VGND sg13g2_decap_8
XFILLER_2_459 VPWR VGND sg13g2_decap_8
XFILLER_46_658 VPWR VGND sg13g2_decap_8
XFILLER_49_67 VPWR VGND sg13g2_decap_8
XFILLER_14_566 VPWR VGND sg13g2_decap_8
XFILLER_26_371 VPWR VGND sg13g2_decap_8
XFILLER_41_385 VPWR VGND sg13g2_decap_8
XFILLER_45_168 VPWR VGND sg13g2_decap_8
XFILLER_5_242 VPWR VGND sg13g2_decap_8
XFILLER_46_7 VPWR VGND sg13g2_decap_8
XFILLER_17_360 VPWR VGND sg13g2_decap_8
XFILLER_36_113 VPWR VGND sg13g2_decap_8
XFILLER_37_603 VPWR VGND sg13g2_fill_2
XFILLER_37_614 VPWR VGND sg13g2_decap_4
XFILLER_49_452 VPWR VGND sg13g2_decap_8
XFILLER_32_396 VPWR VGND sg13g2_decap_8
X_0976_ net108 VGND VPWR _0136_ state\[8\] clknet_5_21__leaf_clk sg13g2_dfrbpq_1
XFILLER_10_39 VPWR VGND sg13g2_decap_8
XFILLER_28_614 VPWR VGND sg13g2_decap_8
XFILLER_15_308 VPWR VGND sg13g2_decap_8
XFILLER_23_363 VPWR VGND sg13g2_decap_8
XFILLER_27_146 VPWR VGND sg13g2_decap_8
XFILLER_35_69 VPWR VGND sg13g2_decap_8
XFILLER_42_105 VPWR VGND sg13g2_decap_8
Xclkbuf_5_20__f_clk clknet_5_20__leaf_clk clknet_4_10_0_clk VPWR VGND sg13g2_buf_16
XFILLER_11_536 VPWR VGND sg13g2_decap_8
XFILLER_3_713 VPWR VGND sg13g2_fill_2
XFILLER_7_518 VPWR VGND sg13g2_decap_8
XFILLER_2_256 VPWR VGND sg13g2_decap_8
XFILLER_18_157 VPWR VGND sg13g2_decap_8
XFILLER_19_658 VPWR VGND sg13g2_decap_8
XFILLER_46_455 VPWR VGND sg13g2_decap_8
XFILLER_14_363 VPWR VGND sg13g2_decap_8
XFILLER_33_149 VPWR VGND sg13g2_decap_8
XFILLER_41_182 VPWR VGND sg13g2_decap_8
X_0830_ VPWR _0046_ state\[22\] VGND sg13g2_inv_1
X_0761_ _0382_ VPWR _0169_ VGND net95 _0031_ sg13g2_o21ai_1
X_0692_ _0250_ net58 _0429_ _0430_ VPWR VGND sg13g2_a21o_1
XFILLER_2_95 VPWR VGND sg13g2_decap_8
XFILLER_37_400 VPWR VGND sg13g2_decap_8
XFILLER_24_149 VPWR VGND sg13g2_decap_8
XFILLER_25_606 VPWR VGND sg13g2_decap_8
XFILLER_37_477 VPWR VGND sg13g2_decap_8
XFILLER_40_609 VPWR VGND sg13g2_decap_4
XFILLER_20_300 VPWR VGND sg13g2_decap_8
XFILLER_20_377 VPWR VGND sg13g2_decap_8
XFILLER_21_38 VPWR VGND sg13g2_decap_8
XFILLER_32_193 VPWR VGND sg13g2_decap_8
X_0959_ net115 VGND VPWR _0119_ daisychain\[55\] clknet_5_10__leaf_clk sg13g2_dfrbpq_1
XFILLER_15_105 VPWR VGND sg13g2_decap_8
XFILLER_28_411 VPWR VGND sg13g2_decap_8
XFILLER_28_488 VPWR VGND sg13g2_decap_8
XFILLER_46_35 VPWR VGND sg13g2_decap_8
XFILLER_11_333 VPWR VGND sg13g2_decap_8
XFILLER_23_160 VPWR VGND sg13g2_decap_8
XFILLER_24_650 VPWR VGND sg13g2_decap_8
XFILLER_43_469 VPWR VGND sg13g2_decap_8
XFILLER_7_315 VPWR VGND sg13g2_decap_8
XFILLER_11_60 VPWR VGND sg13g2_decap_8
XFILLER_3_543 VPWR VGND sg13g2_decap_8
XFILLER_19_400 VPWR VGND sg13g2_decap_8
XFILLER_19_477 VPWR VGND sg13g2_decap_8
XFILLER_21_108 VPWR VGND sg13g2_decap_8
XFILLER_34_469 VPWR VGND sg13g2_decap_8
XFILLER_46_252 VPWR VGND sg13g2_decap_8
XFILLER_47_786 VPWR VGND sg13g2_fill_2
XFILLER_14_160 VPWR VGND sg13g2_decap_8
XFILLER_30_631 VPWR VGND sg13g2_decap_8
XFILLER_30_675 VPWR VGND sg13g2_decap_8
X_0813_ VPWR _0206_ daisychain\[13\] VGND sg13g2_inv_1
XFILLER_35_0 VPWR VGND sg13g2_decap_8
X_0744_ _0331_ VPWR _0152_ VGND net89 _0048_ sg13g2_o21ai_1
X_0675_ net97 VPWR _0417_ VGND net71 state\[53\] sg13g2_o21ai_1
XFILLER_25_403 VPWR VGND sg13g2_decap_8
XFILLER_29_208 VPWR VGND sg13g2_decap_8
XFILLER_37_285 VPWR VGND sg13g2_decap_8
XFILLER_16_49 VPWR VGND sg13g2_decap_8
XFILLER_21_631 VPWR VGND sg13g2_decap_8
XFILLER_40_406 VPWR VGND sg13g2_decap_8
XFILLER_20_174 VPWR VGND sg13g2_decap_8
XFILLER_0_546 VPWR VGND sg13g2_decap_8
XFILLER_48_539 VPWR VGND sg13g2_decap_8
XFILLER_16_469 VPWR VGND sg13g2_decap_8
XFILLER_28_285 VPWR VGND sg13g2_decap_8
XFILLER_29_786 VPWR VGND sg13g2_fill_1
XFILLER_31_417 VPWR VGND sg13g2_decap_8
XFILLER_43_266 VPWR VGND sg13g2_decap_8
XFILLER_44_712 VPWR VGND sg13g2_fill_2
XFILLER_11_130 VPWR VGND sg13g2_decap_8
XFILLER_12_642 VPWR VGND sg13g2_fill_2
XFILLER_8_624 VPWR VGND sg13g2_decap_4
XFILLER_7_112 VPWR VGND sg13g2_decap_8
XFILLER_3_340 VPWR VGND sg13g2_decap_8
X_0460_ VPWR _0024_ state\[63\] VGND sg13g2_inv_1
XFILLER_7_189 VPWR VGND sg13g2_decap_8
XFILLER_19_274 VPWR VGND sg13g2_decap_8
X_1012_ net117 VGND VPWR _0172_ state\[44\] clknet_5_6__leaf_clk sg13g2_dfrbpq_1
XFILLER_34_266 VPWR VGND sg13g2_decap_8
Xheichips25_pudding_124 VPWR VGND uio_oe[1] sg13g2_tiehi
XFILLER_30_494 VPWR VGND sg13g2_decap_8
X_0727_ _0280_ VPWR _0135_ VGND net88 _0061_ sg13g2_o21ai_1
X_0658_ _0112_ _0403_ _0404_ net53 _0241_ VPWR VGND sg13g2_a22oi_1
X_0589_ VGND VPWR net24 daisychain\[30\] _0353_ net38 sg13g2_a21oi_1
XFILLER_25_200 VPWR VGND sg13g2_decap_8
XFILLER_27_48 VPWR VGND sg13g2_decap_8
XFILLER_43_14 VPWR VGND sg13g2_decap_8
XFILLER_21_472 VPWR VGND sg13g2_decap_8
XFILLER_25_277 VPWR VGND sg13g2_decap_8
XFILLER_40_203 VPWR VGND sg13g2_decap_8
XFILLER_5_627 VPWR VGND sg13g2_decap_8
XFILLER_4_137 VPWR VGND sg13g2_decap_8
XFILLER_0_343 VPWR VGND sg13g2_decap_8
XFILLER_48_336 VPWR VGND sg13g2_decap_8
XFILLER_16_266 VPWR VGND sg13g2_decap_8
XFILLER_31_214 VPWR VGND sg13g2_decap_8
XFILLER_44_553 VPWR VGND sg13g2_decap_8
XFILLER_12_494 VPWR VGND sg13g2_decap_8
XFILLER_8_476 VPWR VGND sg13g2_decap_8
X_0512_ _0205_ net65 _0294_ _0295_ VPWR VGND sg13g2_a21o_1
XFILLER_35_531 VPWR VGND sg13g2_decap_8
XFILLER_39_336 VPWR VGND sg13g2_decap_8
XFILLER_22_258 VPWR VGND sg13g2_decap_8
XFILLER_30_291 VPWR VGND sg13g2_decap_8
Xclkbuf_5_1__f_clk clknet_5_1__leaf_clk clknet_4_0_0_clk VPWR VGND sg13g2_buf_16
Xfanout29 net30 net29 VPWR VGND sg13g2_buf_1
XFILLER_38_14 VPWR VGND sg13g2_decap_8
XFILLER_13_258 VPWR VGND sg13g2_decap_8
XFILLER_26_553 VPWR VGND sg13g2_decap_8
XFILLER_41_567 VPWR VGND sg13g2_decap_8
XFILLER_9_207 VPWR VGND sg13g2_decap_8
XFILLER_5_424 VPWR VGND sg13g2_decap_8
XFILLER_0_140 VPWR VGND sg13g2_decap_8
XFILLER_1_630 VPWR VGND sg13g2_decap_8
XFILLER_49_634 VPWR VGND sg13g2_decap_8
XFILLER_17_542 VPWR VGND sg13g2_decap_8
XFILLER_44_350 VPWR VGND sg13g2_decap_8
XFILLER_48_133 VPWR VGND sg13g2_decap_8
XFILLER_32_501 VPWR VGND sg13g2_decap_8
XFILLER_32_578 VPWR VGND sg13g2_decap_8
X_0992_ net109 VGND VPWR _0152_ state\[24\] clknet_5_23__leaf_clk sg13g2_dfrbpq_1
XFILLER_12_291 VPWR VGND sg13g2_decap_8
XFILLER_8_273 VPWR VGND sg13g2_decap_8
XFILLER_39_133 VPWR VGND sg13g2_decap_8
Xclkbuf_4_7_0_clk clknet_0_clk clknet_4_7_0_clk VPWR VGND sg13g2_buf_8
XFILLER_5_95 VPWR VGND sg13g2_decap_8
XFILLER_23_545 VPWR VGND sg13g2_decap_8
XFILLER_27_328 VPWR VGND sg13g2_decap_8
XFILLER_10_228 VPWR VGND sg13g2_decap_8
XFILLER_2_438 VPWR VGND sg13g2_decap_8
XFILLER_49_46 VPWR VGND sg13g2_decap_8
XFILLER_18_339 VPWR VGND sg13g2_decap_8
XFILLER_45_147 VPWR VGND sg13g2_decap_8
XFILLER_46_637 VPWR VGND sg13g2_decap_8
XFILLER_14_545 VPWR VGND sg13g2_decap_8
XFILLER_26_350 VPWR VGND sg13g2_decap_8
XFILLER_41_364 VPWR VGND sg13g2_decap_8
XFILLER_30_81 VPWR VGND sg13g2_decap_8
XFILLER_5_298 VPWR VGND sg13g2_decap_8
XFILLER_5_221 VPWR VGND sg13g2_decap_8
XFILLER_39_7 VPWR VGND sg13g2_decap_8
XFILLER_49_431 VPWR VGND sg13g2_decap_8
XFILLER_36_169 VPWR VGND sg13g2_decap_8
XFILLER_20_515 VPWR VGND sg13g2_decap_8
XFILLER_32_375 VPWR VGND sg13g2_decap_8
X_0975_ net107 VGND VPWR _0135_ state\[7\] clknet_5_21__leaf_clk sg13g2_dfrbpq_1
XFILLER_9_571 VPWR VGND sg13g2_decap_8
XFILLER_10_18 VPWR VGND sg13g2_decap_8
XFILLER_27_125 VPWR VGND sg13g2_decap_8
XFILLER_11_515 VPWR VGND sg13g2_decap_8
XFILLER_23_342 VPWR VGND sg13g2_decap_8
XFILLER_35_48 VPWR VGND sg13g2_decap_8
XFILLER_2_235 VPWR VGND sg13g2_decap_8
XFILLER_4_4 VPWR VGND sg13g2_decap_8
XFILLER_18_136 VPWR VGND sg13g2_decap_8
XFILLER_33_128 VPWR VGND sg13g2_decap_8
XFILLER_46_434 VPWR VGND sg13g2_decap_8
XFILLER_14_342 VPWR VGND sg13g2_decap_8
XFILLER_25_81 VPWR VGND sg13g2_decap_8
XFILLER_41_161 VPWR VGND sg13g2_decap_8
XFILLER_42_684 VPWR VGND sg13g2_fill_1
X_0760_ _0379_ VPWR _0168_ VGND net97 _0030_ sg13g2_o21ai_1
XFILLER_41_91 VPWR VGND sg13g2_decap_8
X_0691_ net4 VPWR _0429_ VGND net58 state\[57\] sg13g2_o21ai_1
XFILLER_6_585 VPWR VGND sg13g2_decap_8
XFILLER_2_74 VPWR VGND sg13g2_decap_8
XFILLER_37_456 VPWR VGND sg13g2_decap_8
XFILLER_24_128 VPWR VGND sg13g2_decap_8
XFILLER_32_172 VPWR VGND sg13g2_decap_8
XFILLER_33_673 VPWR VGND sg13g2_decap_8
XFILLER_20_356 VPWR VGND sg13g2_decap_8
X_0889_ VPWR _0244_ daisychain\[51\] VGND sg13g2_inv_1
X_0958_ net115 VGND VPWR _0118_ daisychain\[54\] clknet_5_11__leaf_clk sg13g2_dfrbpq_1
XFILLER_0_739 VPWR VGND sg13g2_decap_8
XFILLER_28_467 VPWR VGND sg13g2_decap_8
XFILLER_43_448 VPWR VGND sg13g2_decap_8
XFILLER_46_14 VPWR VGND sg13g2_decap_8
XFILLER_11_312 VPWR VGND sg13g2_decap_8
XFILLER_11_389 VPWR VGND sg13g2_decap_8
XFILLER_30_109 VPWR VGND sg13g2_decap_8
XFILLER_3_522 VPWR VGND sg13g2_decap_8
XFILLER_19_456 VPWR VGND sg13g2_decap_8
XFILLER_3_599 VPWR VGND sg13g2_decap_8
XFILLER_46_231 VPWR VGND sg13g2_decap_8
XFILLER_47_721 VPWR VGND sg13g2_decap_8
XFILLER_47_765 VPWR VGND sg13g2_decap_8
XFILLER_34_448 VPWR VGND sg13g2_decap_8
XFILLER_47_798 VPWR VGND sg13g2_decap_8
X_0812_ VPWR _0036_ state\[13\] VGND sg13g2_inv_1
X_0743_ _0328_ VPWR _0151_ VGND net89 _0047_ sg13g2_o21ai_1
XFILLER_28_0 VPWR VGND sg13g2_fill_1
X_0674_ _0116_ _0415_ _0416_ net52 _0245_ VPWR VGND sg13g2_a22oi_1
XFILLER_6_382 VPWR VGND sg13g2_decap_8
XFILLER_37_264 VPWR VGND sg13g2_decap_8
XFILLER_12_109 VPWR VGND sg13g2_decap_8
XFILLER_20_153 VPWR VGND sg13g2_decap_8
XFILLER_21_676 VPWR VGND sg13g2_decap_8
XFILLER_25_459 VPWR VGND sg13g2_decap_8
XFILLER_33_492 VPWR VGND sg13g2_decap_8
XFILLER_4_319 VPWR VGND sg13g2_decap_8
XFILLER_0_525 VPWR VGND sg13g2_decap_8
XFILLER_48_518 VPWR VGND sg13g2_decap_8
XFILLER_16_448 VPWR VGND sg13g2_decap_8
XFILLER_28_264 VPWR VGND sg13g2_decap_8
XFILLER_43_245 VPWR VGND sg13g2_decap_8
XFILLER_11_186 VPWR VGND sg13g2_decap_8
XFILLER_7_168 VPWR VGND sg13g2_decap_8
XFILLER_3_396 VPWR VGND sg13g2_decap_8
XFILLER_19_253 VPWR VGND sg13g2_decap_8
XFILLER_47_595 VPWR VGND sg13g2_decap_8
X_1011_ net117 VGND VPWR _0171_ state\[43\] clknet_5_4__leaf_clk sg13g2_dfrbpq_1
XFILLER_30_473 VPWR VGND sg13g2_decap_8
XFILLER_34_245 VPWR VGND sg13g2_decap_8
Xheichips25_pudding_125 VPWR VGND uio_oe[2] sg13g2_tiehi
X_0726_ _0277_ VPWR _0134_ VGND net83 _0060_ sg13g2_o21ai_1
XFILLER_8_84 VPWR VGND sg13g2_decap_8
XFILLER_27_27 VPWR VGND sg13g2_decap_8
X_0657_ VGND VPWR net30 daisychain\[47\] _0404_ net53 sg13g2_a21oi_1
X_0588_ _0224_ net69 _0351_ _0352_ VPWR VGND sg13g2_a21o_1
XFILLER_25_256 VPWR VGND sg13g2_decap_8
XFILLER_21_451 VPWR VGND sg13g2_decap_8
XFILLER_40_259 VPWR VGND sg13g2_decap_8
XFILLER_5_606 VPWR VGND sg13g2_decap_8
XFILLER_0_322 VPWR VGND sg13g2_decap_8
XFILLER_4_116 VPWR VGND sg13g2_decap_8
XFILLER_49_816 VPWR VGND sg13g2_decap_8
XFILLER_0_399 VPWR VGND sg13g2_decap_8
XFILLER_17_724 VPWR VGND sg13g2_decap_8
XFILLER_29_562 VPWR VGND sg13g2_decap_8
XFILLER_29_573 VPWR VGND sg13g2_fill_2
XFILLER_44_532 VPWR VGND sg13g2_decap_8
XFILLER_48_315 VPWR VGND sg13g2_decap_8
XFILLER_12_473 VPWR VGND sg13g2_decap_8
XFILLER_16_245 VPWR VGND sg13g2_decap_8
XFILLER_25_790 VPWR VGND sg13g2_decap_4
X_0511_ net88 VPWR _0294_ VGND net65 state\[12\] sg13g2_o21ai_1
XFILLER_8_455 VPWR VGND sg13g2_decap_8
XFILLER_39_315 VPWR VGND sg13g2_decap_8
XFILLER_3_193 VPWR VGND sg13g2_decap_8
XFILLER_4_683 VPWR VGND sg13g2_decap_4
XFILLER_35_510 VPWR VGND sg13g2_decap_8
XFILLER_35_587 VPWR VGND sg13g2_decap_8
XFILLER_47_392 VPWR VGND sg13g2_decap_8
XFILLER_22_237 VPWR VGND sg13g2_decap_8
XFILLER_30_270 VPWR VGND sg13g2_decap_8
XFILLER_1_119 VPWR VGND sg13g2_decap_8
X_0709_ VGND VPWR net32 daisychain\[60\] _0443_ net34 sg13g2_a21oi_1
XFILLER_26_532 VPWR VGND sg13g2_decap_8
XFILLER_45_329 VPWR VGND sg13g2_decap_8
XFILLER_13_237 VPWR VGND sg13g2_decap_8
XFILLER_41_546 VPWR VGND sg13g2_decap_8
XFILLER_5_403 VPWR VGND sg13g2_decap_8
XFILLER_0_196 VPWR VGND sg13g2_decap_8
XFILLER_1_686 VPWR VGND sg13g2_decap_8
XFILLER_48_112 VPWR VGND sg13g2_decap_8
XFILLER_49_613 VPWR VGND sg13g2_decap_8
XFILLER_17_521 VPWR VGND sg13g2_decap_8
XFILLER_48_189 VPWR VGND sg13g2_decap_8
XFILLER_12_270 VPWR VGND sg13g2_decap_8
XFILLER_32_557 VPWR VGND sg13g2_decap_8
XFILLER_44_91 VPWR VGND sg13g2_decap_8
X_0991_ net109 VGND VPWR _0151_ state\[23\] clknet_5_23__leaf_clk sg13g2_dfrbpq_1
XFILLER_8_252 VPWR VGND sg13g2_decap_8
XFILLER_5_74 VPWR VGND sg13g2_decap_8
XFILLER_4_480 VPWR VGND sg13g2_decap_8
XFILLER_27_307 VPWR VGND sg13g2_decap_8
XFILLER_28_819 VPWR VGND sg13g2_decap_4
XFILLER_39_112 VPWR VGND sg13g2_decap_8
XFILLER_39_189 VPWR VGND sg13g2_decap_8
XFILLER_10_207 VPWR VGND sg13g2_decap_8
XFILLER_11_719 VPWR VGND sg13g2_fill_1
XFILLER_23_524 VPWR VGND sg13g2_decap_8
XFILLER_35_384 VPWR VGND sg13g2_decap_8
XFILLER_40_49 VPWR VGND sg13g2_decap_8
XFILLER_2_417 VPWR VGND sg13g2_decap_8
XFILLER_49_25 VPWR VGND sg13g2_decap_8
XFILLER_18_318 VPWR VGND sg13g2_decap_8
XFILLER_45_126 VPWR VGND sg13g2_decap_8
XFILLER_46_616 VPWR VGND sg13g2_decap_8
XFILLER_14_524 VPWR VGND sg13g2_decap_8
XFILLER_14_83 VPWR VGND sg13g2_decap_8
XFILLER_41_343 VPWR VGND sg13g2_decap_8
XFILLER_30_60 VPWR VGND sg13g2_decap_8
XFILLER_6_723 VPWR VGND sg13g2_fill_2
XFILLER_5_277 VPWR VGND sg13g2_decap_8
XFILLER_5_200 VPWR VGND sg13g2_decap_8
XFILLER_1_483 VPWR VGND sg13g2_decap_8
XFILLER_39_91 VPWR VGND sg13g2_decap_8
XFILLER_49_487 VPWR VGND sg13g2_decap_8
XFILLER_49_410 VPWR VGND sg13g2_decap_8
XFILLER_17_395 VPWR VGND sg13g2_decap_8
XFILLER_32_354 VPWR VGND sg13g2_decap_8
XFILLER_36_148 VPWR VGND sg13g2_decap_8
XFILLER_45_693 VPWR VGND sg13g2_decap_4
X_0974_ net107 VGND VPWR _0134_ state\[6\] clknet_5_23__leaf_clk sg13g2_dfrbpq_1
XFILLER_9_594 VPWR VGND sg13g2_decap_8
XFILLER_9_550 VPWR VGND sg13g2_decap_8
XFILLER_27_104 VPWR VGND sg13g2_decap_8
XFILLER_28_649 VPWR VGND sg13g2_decap_8
XFILLER_35_27 VPWR VGND sg13g2_decap_8
XFILLER_23_321 VPWR VGND sg13g2_decap_8
XFILLER_23_398 VPWR VGND sg13g2_decap_8
XFILLER_35_181 VPWR VGND sg13g2_decap_8
XFILLER_2_214 VPWR VGND sg13g2_decap_8
XFILLER_3_715 VPWR VGND sg13g2_fill_1
XFILLER_18_115 VPWR VGND sg13g2_decap_8
XFILLER_46_413 VPWR VGND sg13g2_decap_8
XFILLER_14_321 VPWR VGND sg13g2_decap_8
XFILLER_25_60 VPWR VGND sg13g2_decap_8
XFILLER_33_107 VPWR VGND sg13g2_decap_8
XFILLER_41_140 VPWR VGND sg13g2_decap_8
XFILLER_42_630 VPWR VGND sg13g2_decap_8
XFILLER_10_571 VPWR VGND sg13g2_fill_2
XFILLER_14_398 VPWR VGND sg13g2_decap_8
XFILLER_41_70 VPWR VGND sg13g2_decap_8
Xclkbuf_4_6_0_clk clknet_0_clk clknet_4_6_0_clk VPWR VGND sg13g2_buf_8
X_0690_ _0120_ _0427_ _0428_ net47 _0249_ VPWR VGND sg13g2_a22oi_1
XFILLER_6_564 VPWR VGND sg13g2_decap_8
XFILLER_1_280 VPWR VGND sg13g2_decap_8
XFILLER_24_107 VPWR VGND sg13g2_decap_8
XFILLER_2_53 VPWR VGND sg13g2_decap_8
XFILLER_37_435 VPWR VGND sg13g2_decap_8
XFILLER_49_284 VPWR VGND sg13g2_decap_8
XFILLER_17_192 VPWR VGND sg13g2_decap_8
XFILLER_20_335 VPWR VGND sg13g2_decap_8
XFILLER_21_803 VPWR VGND sg13g2_fill_2
XFILLER_32_151 VPWR VGND sg13g2_decap_8
XFILLER_45_490 VPWR VGND sg13g2_decap_8
XFILLER_21_18 VPWR VGND sg13g2_fill_1
X_0888_ VPWR _0010_ state\[51\] VGND sg13g2_inv_1
X_0957_ net116 VGND VPWR _0117_ daisychain\[53\] clknet_5_14__leaf_clk sg13g2_dfrbpq_1
XFILLER_0_707 VPWR VGND sg13g2_decap_8
XFILLER_28_446 VPWR VGND sg13g2_decap_8
XFILLER_43_427 VPWR VGND sg13g2_decap_8
XFILLER_11_368 VPWR VGND sg13g2_decap_8
XFILLER_23_195 VPWR VGND sg13g2_decap_8
XFILLER_11_95 VPWR VGND sg13g2_decap_8
XFILLER_3_501 VPWR VGND sg13g2_decap_8
XFILLER_3_578 VPWR VGND sg13g2_decap_8
XFILLER_19_435 VPWR VGND sg13g2_decap_8
XFILLER_46_210 VPWR VGND sg13g2_decap_8
XFILLER_47_700 VPWR VGND sg13g2_decap_8
XFILLER_14_195 VPWR VGND sg13g2_decap_8
XFILLER_15_641 VPWR VGND sg13g2_fill_2
XFILLER_15_696 VPWR VGND sg13g2_fill_2
XFILLER_34_427 VPWR VGND sg13g2_decap_8
XFILLER_36_92 VPWR VGND sg13g2_decap_8
XFILLER_46_287 VPWR VGND sg13g2_decap_8
X_0811_ VPWR _0205_ daisychain\[12\] VGND sg13g2_inv_1
X_0742_ _0325_ VPWR _0150_ VGND net89 _0046_ sg13g2_o21ai_1
X_0673_ VGND VPWR net30 daisychain\[51\] _0416_ net52 sg13g2_a21oi_1
XFILLER_6_361 VPWR VGND sg13g2_decap_8
XFILLER_25_438 VPWR VGND sg13g2_decap_8
XFILLER_37_243 VPWR VGND sg13g2_decap_8
XFILLER_38_733 VPWR VGND sg13g2_decap_8
XFILLER_20_132 VPWR VGND sg13g2_decap_8
XFILLER_21_611 VPWR VGND sg13g2_fill_2
XFILLER_32_39 VPWR VGND sg13g2_decap_8
XFILLER_33_471 VPWR VGND sg13g2_decap_8
XFILLER_0_504 VPWR VGND sg13g2_decap_8
XFILLER_28_243 VPWR VGND sg13g2_decap_8
XFILLER_29_722 VPWR VGND sg13g2_decap_8
XFILLER_29_777 VPWR VGND sg13g2_decap_4
XFILLER_12_644 VPWR VGND sg13g2_fill_1
XFILLER_16_427 VPWR VGND sg13g2_decap_8
XFILLER_24_493 VPWR VGND sg13g2_decap_4
XFILLER_43_224 VPWR VGND sg13g2_decap_8
XFILLER_11_165 VPWR VGND sg13g2_decap_8
XFILLER_22_83 VPWR VGND sg13g2_decap_8
XFILLER_7_147 VPWR VGND sg13g2_decap_8
XFILLER_4_821 VPWR VGND sg13g2_fill_2
XFILLER_3_375 VPWR VGND sg13g2_decap_8
XFILLER_19_232 VPWR VGND sg13g2_decap_8
XFILLER_34_224 VPWR VGND sg13g2_decap_8
XFILLER_47_574 VPWR VGND sg13g2_decap_8
XFILLER_47_91 VPWR VGND sg13g2_decap_8
X_1010_ net117 VGND VPWR _0170_ state\[42\] clknet_5_6__leaf_clk sg13g2_dfrbpq_1
Xheichips25_pudding_126 VPWR VGND uio_oe[3] sg13g2_tiehi
XFILLER_22_419 VPWR VGND sg13g2_decap_8
XFILLER_30_452 VPWR VGND sg13g2_decap_8
XFILLER_8_63 VPWR VGND sg13g2_decap_8
XFILLER_40_0 VPWR VGND sg13g2_decap_8
X_0725_ _0274_ VPWR _0133_ VGND net83 _0059_ sg13g2_o21ai_1
X_0656_ _0241_ net76 _0402_ _0403_ VPWR VGND sg13g2_a21o_1
XFILLER_38_530 VPWR VGND sg13g2_decap_8
X_0587_ net85 VPWR _0351_ VGND net62 state\[31\] sg13g2_o21ai_1
XFILLER_13_419 VPWR VGND sg13g2_decap_8
XFILLER_21_430 VPWR VGND sg13g2_decap_8
XFILLER_25_235 VPWR VGND sg13g2_decap_8
XFILLER_40_238 VPWR VGND sg13g2_decap_8
XFILLER_41_739 VPWR VGND sg13g2_fill_2
XFILLER_43_49 VPWR VGND sg13g2_decap_8
XFILLER_0_301 VPWR VGND sg13g2_decap_8
XFILLER_0_378 VPWR VGND sg13g2_decap_8
XFILLER_16_224 VPWR VGND sg13g2_decap_8
XFILLER_17_703 VPWR VGND sg13g2_decap_4
XFILLER_29_541 VPWR VGND sg13g2_decap_8
XFILLER_44_511 VPWR VGND sg13g2_decap_8
Xclkbuf_5_26__f_clk clknet_5_26__leaf_clk clknet_4_13_0_clk VPWR VGND sg13g2_buf_16
XFILLER_12_452 VPWR VGND sg13g2_decap_8
XFILLER_17_94 VPWR VGND sg13g2_decap_8
XFILLER_31_249 VPWR VGND sg13g2_decap_8
XFILLER_33_93 VPWR VGND sg13g2_decap_8
XFILLER_44_588 VPWR VGND sg13g2_decap_8
XFILLER_8_434 VPWR VGND sg13g2_decap_8
XFILLER_3_172 VPWR VGND sg13g2_decap_8
X_0510_ _0075_ _0292_ _0293_ net40 _0204_ VPWR VGND sg13g2_a22oi_1
XFILLER_4_662 VPWR VGND sg13g2_decap_8
XFILLER_12_4 VPWR VGND sg13g2_decap_8
XFILLER_22_216 VPWR VGND sg13g2_decap_8
XFILLER_35_566 VPWR VGND sg13g2_decap_8
XFILLER_47_371 VPWR VGND sg13g2_decap_8
X_0708_ _0254_ net56 _0441_ _0442_ VPWR VGND sg13g2_a21o_1
X_0639_ net95 VPWR _0390_ VGND net73 state\[44\] sg13g2_o21ai_1
XFILLER_26_511 VPWR VGND sg13g2_decap_8
XFILLER_38_371 VPWR VGND sg13g2_decap_4
XFILLER_38_49 VPWR VGND sg13g2_decap_8
XFILLER_45_308 VPWR VGND sg13g2_decap_8
XFILLER_13_216 VPWR VGND sg13g2_decap_8
XFILLER_26_588 VPWR VGND sg13g2_decap_8
XFILLER_41_525 VPWR VGND sg13g2_decap_8
XFILLER_5_459 VPWR VGND sg13g2_decap_8
XFILLER_0_175 VPWR VGND sg13g2_decap_8
XFILLER_1_665 VPWR VGND sg13g2_decap_8
XFILLER_48_168 VPWR VGND sg13g2_decap_8
XFILLER_49_669 VPWR VGND sg13g2_decap_8
XFILLER_17_500 VPWR VGND sg13g2_decap_8
XFILLER_17_577 VPWR VGND sg13g2_decap_8
XFILLER_28_82 VPWR VGND sg13g2_decap_8
XFILLER_32_536 VPWR VGND sg13g2_decap_8
XFILLER_44_385 VPWR VGND sg13g2_decap_8
XFILLER_44_70 VPWR VGND sg13g2_decap_8
X_0990_ net109 VGND VPWR _0150_ state\[22\] clknet_5_29__leaf_clk sg13g2_dfrbpq_1
XFILLER_9_743 VPWR VGND sg13g2_fill_1
XFILLER_8_231 VPWR VGND sg13g2_decap_8
XFILLER_5_53 VPWR VGND sg13g2_decap_8
XFILLER_39_168 VPWR VGND sg13g2_decap_8
XFILLER_23_503 VPWR VGND sg13g2_decap_8
XFILLER_24_18 VPWR VGND sg13g2_fill_1
XFILLER_35_363 VPWR VGND sg13g2_decap_8
XFILLER_40_28 VPWR VGND sg13g2_decap_8
XFILLER_19_809 VPWR VGND sg13g2_decap_8
XFILLER_14_503 VPWR VGND sg13g2_decap_8
XFILLER_26_385 VPWR VGND sg13g2_decap_8
XFILLER_41_322 VPWR VGND sg13g2_decap_8
XFILLER_42_812 VPWR VGND sg13g2_decap_8
XFILLER_45_105 VPWR VGND sg13g2_decap_8
XFILLER_14_62 VPWR VGND sg13g2_decap_8
XFILLER_22_580 VPWR VGND sg13g2_decap_8
XFILLER_41_399 VPWR VGND sg13g2_decap_8
XFILLER_1_462 VPWR VGND sg13g2_decap_8
XFILLER_5_256 VPWR VGND sg13g2_decap_8
XFILLER_36_127 VPWR VGND sg13g2_decap_8
XFILLER_39_70 VPWR VGND sg13g2_decap_8
XFILLER_49_466 VPWR VGND sg13g2_decap_8
XFILLER_17_374 VPWR VGND sg13g2_decap_8
XFILLER_32_333 VPWR VGND sg13g2_decap_8
XFILLER_44_182 VPWR VGND sg13g2_decap_8
XFILLER_45_672 VPWR VGND sg13g2_decap_8
X_0973_ net104 VGND VPWR _0133_ state\[5\] clknet_5_19__leaf_clk sg13g2_dfrbpq_1
XFILLER_19_29 VPWR VGND sg13g2_decap_8
XFILLER_23_300 VPWR VGND sg13g2_decap_8
XFILLER_24_812 VPWR VGND sg13g2_decap_8
XFILLER_28_628 VPWR VGND sg13g2_decap_8
XFILLER_35_160 VPWR VGND sg13g2_decap_8
XFILLER_36_661 VPWR VGND sg13g2_fill_1
XFILLER_36_694 VPWR VGND sg13g2_decap_8
XFILLER_42_119 VPWR VGND sg13g2_decap_8
XFILLER_43_609 VPWR VGND sg13g2_decap_8
XFILLER_23_377 VPWR VGND sg13g2_decap_8
XFILLER_3_749 VPWR VGND sg13g2_decap_4
XFILLER_14_300 VPWR VGND sg13g2_decap_8
XFILLER_14_377 VPWR VGND sg13g2_decap_8
XFILLER_26_182 VPWR VGND sg13g2_decap_8
XFILLER_27_683 VPWR VGND sg13g2_decap_8
XFILLER_46_469 VPWR VGND sg13g2_decap_8
XFILLER_10_550 VPWR VGND sg13g2_decap_8
XFILLER_41_196 VPWR VGND sg13g2_decap_8
XFILLER_6_543 VPWR VGND sg13g2_decap_8
XFILLER_2_32 VPWR VGND sg13g2_decap_8
XFILLER_44_7 VPWR VGND sg13g2_decap_8
Xheichips25_pudding VPWR VGND uio_oe[0] sg13g2_tiehi
XFILLER_17_171 VPWR VGND sg13g2_decap_8
XFILLER_18_694 VPWR VGND sg13g2_fill_2
XFILLER_37_414 VPWR VGND sg13g2_decap_8
XFILLER_49_263 VPWR VGND sg13g2_decap_8
XFILLER_20_314 VPWR VGND sg13g2_decap_8
XFILLER_21_815 VPWR VGND sg13g2_decap_8
XFILLER_32_130 VPWR VGND sg13g2_decap_8
X_0956_ net115 VGND VPWR _0116_ daisychain\[52\] clknet_5_14__leaf_clk sg13g2_dfrbpq_1
X_0887_ VPWR _0243_ daisychain\[50\] VGND sg13g2_inv_1
XFILLER_28_425 VPWR VGND sg13g2_decap_8
XFILLER_46_49 VPWR VGND sg13g2_decap_8
Xclkbuf_5_7__f_clk clknet_5_7__leaf_clk clknet_4_3_0_clk VPWR VGND sg13g2_buf_16
XFILLER_15_119 VPWR VGND sg13g2_decap_8
XFILLER_23_174 VPWR VGND sg13g2_decap_8
XFILLER_24_664 VPWR VGND sg13g2_decap_8
XFILLER_43_406 VPWR VGND sg13g2_decap_8
XFILLER_11_347 VPWR VGND sg13g2_decap_8
XFILLER_7_329 VPWR VGND sg13g2_decap_8
XFILLER_11_74 VPWR VGND sg13g2_decap_8
XFILLER_3_557 VPWR VGND sg13g2_decap_8
XFILLER_19_414 VPWR VGND sg13g2_decap_8
XFILLER_34_406 VPWR VGND sg13g2_decap_8
XFILLER_36_71 VPWR VGND sg13g2_decap_8
XFILLER_46_266 VPWR VGND sg13g2_decap_8
XFILLER_47_745 VPWR VGND sg13g2_fill_2
XFILLER_14_174 VPWR VGND sg13g2_decap_8
XFILLER_30_689 VPWR VGND sg13g2_decap_8
XFILLER_42_483 VPWR VGND sg13g2_decap_8
X_0810_ VPWR _0035_ state\[12\] VGND sg13g2_inv_1
X_0741_ _0322_ VPWR _0149_ VGND net90 _0045_ sg13g2_o21ai_1
X_0672_ _0245_ net75 _0414_ _0415_ VPWR VGND sg13g2_a21o_1
XFILLER_6_340 VPWR VGND sg13g2_decap_8
XFILLER_37_222 VPWR VGND sg13g2_decap_8
XFILLER_25_417 VPWR VGND sg13g2_decap_8
XFILLER_33_450 VPWR VGND sg13g2_decap_8
XFILLER_37_299 VPWR VGND sg13g2_decap_8
XFILLER_20_111 VPWR VGND sg13g2_decap_8
XFILLER_20_188 VPWR VGND sg13g2_decap_8
XFILLER_21_645 VPWR VGND sg13g2_fill_2
XFILLER_32_18 VPWR VGND sg13g2_decap_8
X_0939_ net101 VGND VPWR _0099_ daisychain\[35\] clknet_5_10__leaf_clk sg13g2_dfrbpq_1
XFILLER_16_406 VPWR VGND sg13g2_decap_8
XFILLER_28_222 VPWR VGND sg13g2_decap_8
XFILLER_28_299 VPWR VGND sg13g2_decap_8
XFILLER_43_203 VPWR VGND sg13g2_decap_8
Xclkbuf_4_5_0_clk clknet_0_clk clknet_4_5_0_clk VPWR VGND sg13g2_buf_8
XFILLER_11_144 VPWR VGND sg13g2_decap_8
XFILLER_24_472 VPWR VGND sg13g2_decap_8
XFILLER_22_62 VPWR VGND sg13g2_decap_8
XFILLER_3_354 VPWR VGND sg13g2_decap_8
XFILLER_7_126 VPWR VGND sg13g2_decap_8
XFILLER_0_0 VPWR VGND sg13g2_decap_8
XFILLER_19_211 VPWR VGND sg13g2_decap_8
XFILLER_19_288 VPWR VGND sg13g2_decap_8
XFILLER_34_203 VPWR VGND sg13g2_decap_8
XFILLER_47_553 VPWR VGND sg13g2_decap_8
XFILLER_47_70 VPWR VGND sg13g2_decap_8
Xheichips25_pudding_127 VPWR VGND uio_oe[4] sg13g2_tiehi
XFILLER_15_483 VPWR VGND sg13g2_decap_8
XFILLER_30_431 VPWR VGND sg13g2_decap_8
XFILLER_42_280 VPWR VGND sg13g2_decap_8
XFILLER_8_42 VPWR VGND sg13g2_decap_8
X_0724_ _0271_ VPWR _0132_ VGND net83 _0058_ sg13g2_o21ai_1
X_0655_ net98 VPWR _0402_ VGND net76 state\[48\] sg13g2_o21ai_1
X_0586_ _0094_ _0349_ _0350_ net38 _0223_ VPWR VGND sg13g2_a22oi_1
XFILLER_25_214 VPWR VGND sg13g2_decap_8
XFILLER_40_217 VPWR VGND sg13g2_decap_8
XFILLER_43_28 VPWR VGND sg13g2_decap_8
XFILLER_21_486 VPWR VGND sg13g2_decap_8
XFILLER_0_357 VPWR VGND sg13g2_decap_8
XFILLER_16_203 VPWR VGND sg13g2_decap_8
XFILLER_17_715 VPWR VGND sg13g2_fill_1
XFILLER_17_73 VPWR VGND sg13g2_decap_8
XFILLER_44_567 VPWR VGND sg13g2_decap_8
XFILLER_12_431 VPWR VGND sg13g2_decap_8
XFILLER_31_228 VPWR VGND sg13g2_decap_8
XFILLER_33_72 VPWR VGND sg13g2_decap_8
XFILLER_40_740 VPWR VGND sg13g2_fill_1
XFILLER_8_413 VPWR VGND sg13g2_decap_8
XFILLER_3_151 VPWR VGND sg13g2_decap_8
XFILLER_4_641 VPWR VGND sg13g2_decap_8
XFILLER_47_350 VPWR VGND sg13g2_decap_8
XFILLER_15_280 VPWR VGND sg13g2_decap_8
XFILLER_35_545 VPWR VGND sg13g2_decap_8
X_0707_ net80 VPWR _0441_ VGND net56 state\[61\] sg13g2_o21ai_1
XFILLER_7_490 VPWR VGND sg13g2_decap_8
X_0638_ _0107_ _0388_ _0389_ net50 _0236_ VPWR VGND sg13g2_a22oi_1
X_0569_ VGND VPWR net23 daisychain\[25\] _0338_ net38 sg13g2_a21oi_1
XFILLER_26_567 VPWR VGND sg13g2_decap_8
XFILLER_38_350 VPWR VGND sg13g2_decap_8
XFILLER_41_504 VPWR VGND sg13g2_decap_8
XFILLER_21_283 VPWR VGND sg13g2_decap_8
XFILLER_1_644 VPWR VGND sg13g2_decap_8
XFILLER_5_438 VPWR VGND sg13g2_decap_8
XFILLER_0_154 VPWR VGND sg13g2_decap_8
XFILLER_28_61 VPWR VGND sg13g2_decap_8
XFILLER_36_309 VPWR VGND sg13g2_decap_8
XFILLER_48_147 VPWR VGND sg13g2_decap_8
XFILLER_49_648 VPWR VGND sg13g2_decap_8
XFILLER_17_556 VPWR VGND sg13g2_decap_8
XFILLER_29_383 VPWR VGND sg13g2_decap_8
XFILLER_32_515 VPWR VGND sg13g2_decap_8
XFILLER_44_364 VPWR VGND sg13g2_decap_8
XFILLER_40_581 VPWR VGND sg13g2_decap_8
XFILLER_8_287 VPWR VGND sg13g2_decap_8
XFILLER_8_210 VPWR VGND sg13g2_decap_8
XFILLER_5_32 VPWR VGND sg13g2_decap_8
XFILLER_35_342 VPWR VGND sg13g2_decap_8
XFILLER_39_147 VPWR VGND sg13g2_decap_8
XFILLER_23_559 VPWR VGND sg13g2_decap_8
XFILLER_31_592 VPWR VGND sg13g2_fill_2
XFILLER_14_559 VPWR VGND sg13g2_decap_8
XFILLER_26_364 VPWR VGND sg13g2_decap_8
XFILLER_41_301 VPWR VGND sg13g2_decap_8
XFILLER_14_41 VPWR VGND sg13g2_decap_8
XFILLER_41_378 VPWR VGND sg13g2_decap_8
XFILLER_5_235 VPWR VGND sg13g2_decap_8
XFILLER_1_441 VPWR VGND sg13g2_decap_8
XFILLER_30_95 VPWR VGND sg13g2_decap_8
XFILLER_17_353 VPWR VGND sg13g2_decap_8
XFILLER_29_180 VPWR VGND sg13g2_decap_8
XFILLER_36_106 VPWR VGND sg13g2_decap_8
XFILLER_37_618 VPWR VGND sg13g2_fill_2
XFILLER_45_651 VPWR VGND sg13g2_decap_8
XFILLER_49_445 VPWR VGND sg13g2_decap_8
XFILLER_20_529 VPWR VGND sg13g2_decap_4
XFILLER_32_312 VPWR VGND sg13g2_decap_8
XFILLER_32_389 VPWR VGND sg13g2_decap_8
XFILLER_44_161 VPWR VGND sg13g2_decap_8
X_0972_ net104 VGND VPWR _0132_ state\[4\] clknet_5_18__leaf_clk sg13g2_dfrbpq_1
XFILLER_9_585 VPWR VGND sg13g2_decap_4
XFILLER_28_607 VPWR VGND sg13g2_decap_8
XFILLER_23_356 VPWR VGND sg13g2_decap_8
XFILLER_27_139 VPWR VGND sg13g2_decap_8
XFILLER_11_529 VPWR VGND sg13g2_decap_8
XFILLER_2_249 VPWR VGND sg13g2_decap_8
XFILLER_46_448 VPWR VGND sg13g2_decap_8
XFILLER_14_356 VPWR VGND sg13g2_decap_8
XFILLER_25_95 VPWR VGND sg13g2_decap_8
XFILLER_26_161 VPWR VGND sg13g2_decap_8
XFILLER_30_805 VPWR VGND sg13g2_fill_2
XFILLER_41_175 VPWR VGND sg13g2_decap_8
XFILLER_42_676 VPWR VGND sg13g2_fill_1
XFILLER_6_599 VPWR VGND sg13g2_decap_8
XFILLER_6_522 VPWR VGND sg13g2_decap_8
XFILLER_2_11 VPWR VGND sg13g2_decap_8
XFILLER_2_772 VPWR VGND sg13g2_fill_1
XFILLER_37_7 VPWR VGND sg13g2_decap_8
XFILLER_49_242 VPWR VGND sg13g2_decap_8
XFILLER_17_150 VPWR VGND sg13g2_decap_8
XFILLER_2_88 VPWR VGND sg13g2_decap_8
XFILLER_32_186 VPWR VGND sg13g2_decap_8
XFILLER_33_687 VPWR VGND sg13g2_decap_4
X_0886_ VPWR _0009_ state\[50\] VGND sg13g2_inv_1
X_0955_ net119 VGND VPWR _0115_ daisychain\[51\] clknet_5_12__leaf_clk sg13g2_dfrbpq_1
XFILLER_9_382 VPWR VGND sg13g2_decap_8
XFILLER_28_404 VPWR VGND sg13g2_decap_8
XFILLER_46_28 VPWR VGND sg13g2_decap_8
XFILLER_11_326 VPWR VGND sg13g2_decap_8
XFILLER_23_153 VPWR VGND sg13g2_decap_8
XFILLER_24_643 VPWR VGND sg13g2_decap_8
XFILLER_11_53 VPWR VGND sg13g2_decap_8
XFILLER_3_536 VPWR VGND sg13g2_decap_8
XFILLER_7_308 VPWR VGND sg13g2_decap_8
XFILLER_2_4 VPWR VGND sg13g2_decap_8
XFILLER_36_50 VPWR VGND sg13g2_decap_8
XFILLER_46_245 VPWR VGND sg13g2_decap_8
XFILLER_47_735 VPWR VGND sg13g2_decap_4
XFILLER_47_779 VPWR VGND sg13g2_decap_8
XFILLER_14_153 VPWR VGND sg13g2_decap_8
XFILLER_30_624 VPWR VGND sg13g2_decap_8
XFILLER_42_462 VPWR VGND sg13g2_decap_8
X_0740_ _0319_ VPWR _0148_ VGND net90 _0044_ sg13g2_o21ai_1
X_0671_ net97 VPWR _0414_ VGND net75 state\[52\] sg13g2_o21ai_1
XFILLER_6_396 VPWR VGND sg13g2_decap_8
XFILLER_37_201 VPWR VGND sg13g2_decap_8
XFILLER_21_624 VPWR VGND sg13g2_decap_8
XFILLER_37_278 VPWR VGND sg13g2_decap_8
XFILLER_20_167 VPWR VGND sg13g2_decap_8
X_0869_ VPWR _0234_ daisychain\[41\] VGND sg13g2_inv_1
X_0938_ net114 VGND VPWR _0098_ daisychain\[34\] clknet_5_1__leaf_clk sg13g2_dfrbpq_1
XFILLER_0_539 VPWR VGND sg13g2_decap_8
XFILLER_28_201 VPWR VGND sg13g2_decap_8
XFILLER_28_278 VPWR VGND sg13g2_decap_8
XFILLER_43_259 VPWR VGND sg13g2_decap_8
XFILLER_11_123 VPWR VGND sg13g2_decap_8
XFILLER_12_635 VPWR VGND sg13g2_fill_2
XFILLER_22_41 VPWR VGND sg13g2_decap_8
XFILLER_24_451 VPWR VGND sg13g2_decap_8
XFILLER_7_105 VPWR VGND sg13g2_decap_8
XFILLER_3_333 VPWR VGND sg13g2_decap_8
XFILLER_4_801 VPWR VGND sg13g2_fill_1
XFILLER_47_532 VPWR VGND sg13g2_decap_8
XFILLER_15_462 VPWR VGND sg13g2_decap_8
XFILLER_19_267 VPWR VGND sg13g2_decap_8
XFILLER_30_410 VPWR VGND sg13g2_decap_8
XFILLER_34_259 VPWR VGND sg13g2_decap_8
Xheichips25_pudding_128 VPWR VGND uio_oe[5] sg13g2_tiehi
XFILLER_30_487 VPWR VGND sg13g2_decap_8
X_0723_ _0268_ VPWR _0131_ VGND net82 _0057_ sg13g2_o21ai_1
XFILLER_8_98 VPWR VGND sg13g2_decap_8
XFILLER_8_21 VPWR VGND sg13g2_decap_8
X_0654_ _0111_ _0400_ _0401_ net54 _0240_ VPWR VGND sg13g2_a22oi_1
X_0585_ VGND VPWR net24 daisychain\[29\] _0350_ net38 sg13g2_a21oi_1
XFILLER_6_193 VPWR VGND sg13g2_decap_8
XFILLER_38_554 VPWR VGND sg13g2_decap_4
XFILLER_21_465 VPWR VGND sg13g2_decap_8
XFILLER_0_336 VPWR VGND sg13g2_decap_8
XFILLER_48_329 VPWR VGND sg13g2_decap_8
XFILLER_12_410 VPWR VGND sg13g2_decap_8
XFILLER_16_259 VPWR VGND sg13g2_decap_8
XFILLER_17_30 VPWR VGND sg13g2_fill_2
XFILLER_17_738 VPWR VGND sg13g2_fill_2
XFILLER_31_207 VPWR VGND sg13g2_decap_8
XFILLER_44_546 VPWR VGND sg13g2_decap_8
XFILLER_12_487 VPWR VGND sg13g2_decap_8
XFILLER_33_51 VPWR VGND sg13g2_decap_8
XFILLER_8_469 VPWR VGND sg13g2_decap_8
XFILLER_3_130 VPWR VGND sg13g2_decap_8
XFILLER_4_620 VPWR VGND sg13g2_decap_8
XFILLER_35_524 VPWR VGND sg13g2_decap_8
XFILLER_39_329 VPWR VGND sg13g2_decap_8
XFILLER_30_284 VPWR VGND sg13g2_decap_8
Xclkbuf_4_4_0_clk clknet_0_clk clknet_4_4_0_clk VPWR VGND sg13g2_buf_8
X_0706_ _0124_ _0439_ _0440_ net34 _0253_ VPWR VGND sg13g2_a22oi_1
X_0637_ VGND VPWR net29 daisychain\[42\] _0389_ net50 sg13g2_a21oi_1
X_0568_ _0219_ net61 _0336_ _0337_ VPWR VGND sg13g2_a21o_1
X_0499_ net83 VPWR _0285_ VGND net60 state\[9\] sg13g2_o21ai_1
XFILLER_26_546 VPWR VGND sg13g2_decap_8
XFILLER_38_395 VPWR VGND sg13g2_decap_8
XFILLER_21_262 VPWR VGND sg13g2_decap_8
XFILLER_5_417 VPWR VGND sg13g2_decap_8
XFILLER_0_133 VPWR VGND sg13g2_decap_8
XFILLER_1_623 VPWR VGND sg13g2_decap_8
XFILLER_17_535 VPWR VGND sg13g2_decap_8
XFILLER_28_40 VPWR VGND sg13g2_decap_8
XFILLER_29_362 VPWR VGND sg13g2_decap_8
XFILLER_45_811 VPWR VGND sg13g2_decap_8
XFILLER_45_822 VPWR VGND sg13g2_fill_1
XFILLER_48_126 VPWR VGND sg13g2_decap_8
XFILLER_49_627 VPWR VGND sg13g2_decap_8
XFILLER_40_560 VPWR VGND sg13g2_decap_8
XFILLER_44_343 VPWR VGND sg13g2_decap_8
XFILLER_12_284 VPWR VGND sg13g2_decap_8
XFILLER_8_266 VPWR VGND sg13g2_decap_8
XFILLER_5_11 VPWR VGND sg13g2_decap_8
XFILLER_39_126 VPWR VGND sg13g2_decap_8
XFILLER_5_88 VPWR VGND sg13g2_decap_8
XFILLER_4_494 VPWR VGND sg13g2_decap_8
XFILLER_23_538 VPWR VGND sg13g2_decap_8
XFILLER_35_321 VPWR VGND sg13g2_decap_8
XFILLER_35_398 VPWR VGND sg13g2_decap_8
XFILLER_48_693 VPWR VGND sg13g2_decap_8
XFILLER_31_571 VPWR VGND sg13g2_decap_8
XFILLER_49_39 VPWR VGND sg13g2_decap_8
XFILLER_27_822 VPWR VGND sg13g2_fill_1
XFILLER_14_20 VPWR VGND sg13g2_decap_8
XFILLER_14_538 VPWR VGND sg13g2_decap_8
XFILLER_26_343 VPWR VGND sg13g2_decap_8
XFILLER_41_357 VPWR VGND sg13g2_decap_8
XFILLER_14_97 VPWR VGND sg13g2_decap_8
XFILLER_30_74 VPWR VGND sg13g2_decap_8
XFILLER_5_214 VPWR VGND sg13g2_decap_8
XFILLER_1_420 VPWR VGND sg13g2_decap_8
XFILLER_1_497 VPWR VGND sg13g2_decap_8
XFILLER_49_424 VPWR VGND sg13g2_decap_8
XFILLER_17_332 VPWR VGND sg13g2_decap_8
XFILLER_44_140 VPWR VGND sg13g2_decap_8
XFILLER_45_630 VPWR VGND sg13g2_decap_8
XFILLER_13_593 VPWR VGND sg13g2_decap_8
XFILLER_20_508 VPWR VGND sg13g2_decap_8
XFILLER_32_368 VPWR VGND sg13g2_decap_8
X_0971_ net103 VGND VPWR _0131_ state\[3\] clknet_5_18__leaf_clk sg13g2_dfrbpq_1
XFILLER_9_564 VPWR VGND sg13g2_decap_8
XFILLER_4_291 VPWR VGND sg13g2_decap_8
XFILLER_27_118 VPWR VGND sg13g2_decap_8
XFILLER_48_490 VPWR VGND sg13g2_decap_8
XFILLER_11_508 VPWR VGND sg13g2_decap_8
XFILLER_23_335 VPWR VGND sg13g2_decap_8
XFILLER_35_195 VPWR VGND sg13g2_decap_8
XFILLER_36_674 VPWR VGND sg13g2_fill_1
XFILLER_2_228 VPWR VGND sg13g2_decap_8
XFILLER_18_129 VPWR VGND sg13g2_decap_8
XFILLER_26_140 VPWR VGND sg13g2_decap_8
XFILLER_46_427 VPWR VGND sg13g2_decap_8
XFILLER_14_335 VPWR VGND sg13g2_decap_8
XFILLER_25_74 VPWR VGND sg13g2_decap_8
XFILLER_41_154 VPWR VGND sg13g2_decap_8
XFILLER_6_501 VPWR VGND sg13g2_decap_8
XFILLER_41_84 VPWR VGND sg13g2_decap_8
XFILLER_6_578 VPWR VGND sg13g2_decap_8
XFILLER_1_294 VPWR VGND sg13g2_decap_8
XFILLER_2_67 VPWR VGND sg13g2_decap_8
XFILLER_2_762 VPWR VGND sg13g2_fill_2
XFILLER_37_449 VPWR VGND sg13g2_decap_8
XFILLER_49_298 VPWR VGND sg13g2_decap_8
XFILLER_49_221 VPWR VGND sg13g2_decap_8
XFILLER_32_165 VPWR VGND sg13g2_decap_8
XFILLER_20_349 VPWR VGND sg13g2_decap_8
X_0885_ VPWR _0242_ daisychain\[49\] VGND sg13g2_inv_1
X_0954_ net119 VGND VPWR _0114_ daisychain\[50\] clknet_5_14__leaf_clk sg13g2_dfrbpq_1
XFILLER_9_361 VPWR VGND sg13g2_decap_8
XFILLER_11_305 VPWR VGND sg13g2_decap_8
XFILLER_23_132 VPWR VGND sg13g2_decap_8
XFILLER_24_622 VPWR VGND sg13g2_decap_8
XFILLER_36_493 VPWR VGND sg13g2_decap_8
XFILLER_11_32 VPWR VGND sg13g2_decap_8
XFILLER_3_515 VPWR VGND sg13g2_decap_8
XFILLER_46_224 VPWR VGND sg13g2_decap_8
XFILLER_47_714 VPWR VGND sg13g2_decap_8
XFILLER_47_747 VPWR VGND sg13g2_fill_1
XFILLER_14_132 VPWR VGND sg13g2_decap_8
XFILLER_15_655 VPWR VGND sg13g2_fill_2
XFILLER_19_449 VPWR VGND sg13g2_decap_8
XFILLER_27_482 VPWR VGND sg13g2_decap_8
XFILLER_42_441 VPWR VGND sg13g2_decap_8
XFILLER_47_758 VPWR VGND sg13g2_decap_8
XFILLER_10_382 VPWR VGND sg13g2_decap_8
X_0670_ _0115_ _0412_ _0413_ net52 _0244_ VPWR VGND sg13g2_a22oi_1
XFILLER_2_592 VPWR VGND sg13g2_decap_8
XFILLER_6_375 VPWR VGND sg13g2_decap_8
XFILLER_37_257 VPWR VGND sg13g2_decap_8
XFILLER_18_493 VPWR VGND sg13g2_fill_1
XFILLER_20_146 VPWR VGND sg13g2_decap_8
XFILLER_33_485 VPWR VGND sg13g2_decap_8
X_0868_ VPWR _0031_ state\[41\] VGND sg13g2_inv_1
X_0937_ net114 VGND VPWR _0097_ daisychain\[33\] clknet_5_1__leaf_clk sg13g2_dfrbpq_1
Xclkbuf_5_15__f_clk clknet_5_15__leaf_clk clknet_4_7_0_clk VPWR VGND sg13g2_buf_16
X_0799_ VPWR _0199_ daisychain\[6\] VGND sg13g2_inv_1
XFILLER_0_518 VPWR VGND sg13g2_decap_8
XFILLER_28_257 VPWR VGND sg13g2_decap_8
XFILLER_43_238 VPWR VGND sg13g2_decap_8
XFILLER_11_102 VPWR VGND sg13g2_decap_8
XFILLER_11_179 VPWR VGND sg13g2_decap_8
XFILLER_12_658 VPWR VGND sg13g2_decap_4
XFILLER_22_97 VPWR VGND sg13g2_decap_8
XFILLER_3_312 VPWR VGND sg13g2_decap_8
XFILLER_3_389 VPWR VGND sg13g2_decap_8
XFILLER_19_246 VPWR VGND sg13g2_decap_8
XFILLER_47_511 VPWR VGND sg13g2_decap_8
XFILLER_47_588 VPWR VGND sg13g2_decap_8
XFILLER_15_441 VPWR VGND sg13g2_decap_8
XFILLER_34_238 VPWR VGND sg13g2_decap_8
Xheichips25_pudding_129 VPWR VGND uio_oe[6] sg13g2_tiehi
XFILLER_30_466 VPWR VGND sg13g2_decap_8
X_0722_ _0265_ VPWR _0130_ VGND net82 _0054_ sg13g2_o21ai_1
X_0653_ VGND VPWR net30 daisychain\[46\] _0401_ net54 sg13g2_a21oi_1
XFILLER_8_77 VPWR VGND sg13g2_decap_8
XFILLER_7_673 VPWR VGND sg13g2_fill_1
XFILLER_6_172 VPWR VGND sg13g2_decap_8
X_0584_ _0223_ net62 _0348_ _0349_ VPWR VGND sg13g2_a21o_1
XFILLER_18_290 VPWR VGND sg13g2_decap_8
XFILLER_25_249 VPWR VGND sg13g2_decap_8
XFILLER_21_444 VPWR VGND sg13g2_decap_8
XFILLER_33_282 VPWR VGND sg13g2_decap_8
XFILLER_0_315 VPWR VGND sg13g2_decap_8
XFILLER_1_816 VPWR VGND sg13g2_decap_8
XFILLER_4_109 VPWR VGND sg13g2_decap_8
XFILLER_29_555 VPWR VGND sg13g2_decap_8
XFILLER_48_308 VPWR VGND sg13g2_decap_8
XFILLER_49_809 VPWR VGND sg13g2_decap_8
XFILLER_16_238 VPWR VGND sg13g2_decap_8
XFILLER_24_282 VPWR VGND sg13g2_decap_8
XFILLER_25_794 VPWR VGND sg13g2_fill_1
XFILLER_33_30 VPWR VGND sg13g2_decap_8
XFILLER_44_525 VPWR VGND sg13g2_decap_8
XFILLER_12_466 VPWR VGND sg13g2_decap_8
XFILLER_8_448 VPWR VGND sg13g2_decap_8
XFILLER_39_308 VPWR VGND sg13g2_decap_8
XFILLER_3_186 VPWR VGND sg13g2_decap_8
XFILLER_4_687 VPWR VGND sg13g2_fill_2
XFILLER_4_676 VPWR VGND sg13g2_decap_8
XFILLER_35_503 VPWR VGND sg13g2_decap_8
XFILLER_47_385 VPWR VGND sg13g2_decap_8
XFILLER_30_263 VPWR VGND sg13g2_decap_8
X_0705_ VGND VPWR net32 daisychain\[59\] _0440_ net34 sg13g2_a21oi_1
X_0636_ _0236_ net73 _0387_ _0388_ VPWR VGND sg13g2_a21o_1
X_0567_ net84 VPWR _0336_ VGND net61 state\[26\] sg13g2_o21ai_1
X_0498_ _0072_ _0283_ _0284_ net40 _0201_ VPWR VGND sg13g2_a22oi_1
XFILLER_26_525 VPWR VGND sg13g2_decap_8
XFILLER_41_539 VPWR VGND sg13g2_decap_8
XFILLER_21_241 VPWR VGND sg13g2_decap_8
XFILLER_0_112 VPWR VGND sg13g2_decap_8
XFILLER_1_602 VPWR VGND sg13g2_decap_8
XFILLER_1_679 VPWR VGND sg13g2_decap_8
XFILLER_48_105 VPWR VGND sg13g2_decap_8
XFILLER_49_606 VPWR VGND sg13g2_decap_8
XFILLER_0_189 VPWR VGND sg13g2_decap_8
XFILLER_17_514 VPWR VGND sg13g2_decap_8
XFILLER_28_96 VPWR VGND sg13g2_decap_8
XFILLER_29_341 VPWR VGND sg13g2_decap_8
XFILLER_44_322 VPWR VGND sg13g2_decap_8
XFILLER_12_263 VPWR VGND sg13g2_decap_8
XFILLER_44_399 VPWR VGND sg13g2_decap_8
XFILLER_44_84 VPWR VGND sg13g2_decap_8
XFILLER_9_702 VPWR VGND sg13g2_fill_2
XFILLER_8_245 VPWR VGND sg13g2_decap_8
XFILLER_5_67 VPWR VGND sg13g2_decap_8
XFILLER_4_473 VPWR VGND sg13g2_decap_8
XFILLER_10_4 VPWR VGND sg13g2_decap_8
XFILLER_39_105 VPWR VGND sg13g2_decap_8
XFILLER_48_672 VPWR VGND sg13g2_decap_8
XFILLER_23_517 VPWR VGND sg13g2_decap_8
XFILLER_35_300 VPWR VGND sg13g2_decap_8
XFILLER_35_377 VPWR VGND sg13g2_decap_8
XFILLER_47_182 VPWR VGND sg13g2_decap_8
XFILLER_31_550 VPWR VGND sg13g2_decap_8
XFILLER_31_594 VPWR VGND sg13g2_fill_1
X_0619_ net97 VPWR _0375_ VGND net75 state\[39\] sg13g2_o21ai_1
XFILLER_49_18 VPWR VGND sg13g2_decap_8
XFILLER_26_322 VPWR VGND sg13g2_decap_8
XFILLER_38_182 VPWR VGND sg13g2_decap_8
XFILLER_39_672 VPWR VGND sg13g2_fill_2
XFILLER_39_683 VPWR VGND sg13g2_fill_2
XFILLER_45_119 VPWR VGND sg13g2_decap_8
XFILLER_46_609 VPWR VGND sg13g2_decap_8
XFILLER_14_517 VPWR VGND sg13g2_decap_8
XFILLER_14_76 VPWR VGND sg13g2_decap_8
XFILLER_22_594 VPWR VGND sg13g2_decap_8
XFILLER_26_399 VPWR VGND sg13g2_decap_8
XFILLER_41_336 VPWR VGND sg13g2_decap_8
XFILLER_30_53 VPWR VGND sg13g2_decap_8
XFILLER_1_476 VPWR VGND sg13g2_decap_8
XFILLER_39_84 VPWR VGND sg13g2_decap_8
Xclkbuf_4_3_0_clk clknet_0_clk clknet_4_3_0_clk VPWR VGND sg13g2_buf_8
XFILLER_49_403 VPWR VGND sg13g2_decap_8
XFILLER_17_311 VPWR VGND sg13g2_decap_8
XFILLER_17_388 VPWR VGND sg13g2_decap_8
XFILLER_32_347 VPWR VGND sg13g2_decap_8
XFILLER_44_196 VPWR VGND sg13g2_decap_8
XFILLER_45_686 VPWR VGND sg13g2_decap_8
XFILLER_45_697 VPWR VGND sg13g2_fill_2
XFILLER_13_583 VPWR VGND sg13g2_decap_8
X_0970_ net103 VGND VPWR _0130_ state\[2\] clknet_5_28__leaf_clk sg13g2_dfrbpq_1
XFILLER_9_543 VPWR VGND sg13g2_decap_8
XFILLER_5_782 VPWR VGND sg13g2_fill_2
XFILLER_4_270 VPWR VGND sg13g2_decap_8
XFILLER_23_314 VPWR VGND sg13g2_decap_8
XFILLER_35_174 VPWR VGND sg13g2_decap_8
XFILLER_2_207 VPWR VGND sg13g2_decap_8
XFILLER_46_406 VPWR VGND sg13g2_decap_8
XFILLER_14_314 VPWR VGND sg13g2_decap_8
XFILLER_18_108 VPWR VGND sg13g2_decap_8
XFILLER_25_53 VPWR VGND sg13g2_decap_8
XFILLER_26_196 VPWR VGND sg13g2_decap_8
XFILLER_27_697 VPWR VGND sg13g2_decap_4
XFILLER_42_623 VPWR VGND sg13g2_decap_8
XFILLER_10_564 VPWR VGND sg13g2_decap_8
XFILLER_22_391 VPWR VGND sg13g2_decap_8
XFILLER_30_807 VPWR VGND sg13g2_fill_1
XFILLER_30_818 VPWR VGND sg13g2_decap_4
XFILLER_41_133 VPWR VGND sg13g2_decap_8
XFILLER_41_63 VPWR VGND sg13g2_decap_8
XFILLER_2_785 VPWR VGND sg13g2_decap_4
XFILLER_6_557 VPWR VGND sg13g2_decap_8
XFILLER_18_642 VPWR VGND sg13g2_decap_4
XFILLER_1_273 VPWR VGND sg13g2_decap_8
XFILLER_2_46 VPWR VGND sg13g2_decap_8
XFILLER_37_428 VPWR VGND sg13g2_decap_8
XFILLER_49_277 VPWR VGND sg13g2_decap_8
XFILLER_49_200 VPWR VGND sg13g2_decap_8
XFILLER_17_185 VPWR VGND sg13g2_decap_8
XFILLER_20_328 VPWR VGND sg13g2_decap_8
XFILLER_32_144 VPWR VGND sg13g2_decap_8
XFILLER_45_483 VPWR VGND sg13g2_decap_8
XFILLER_13_391 VPWR VGND sg13g2_decap_8
X_0884_ VPWR _0008_ state\[49\] VGND sg13g2_inv_1
X_0953_ net119 VGND VPWR _0113_ daisychain\[49\] clknet_5_14__leaf_clk sg13g2_dfrbpq_1
XFILLER_9_340 VPWR VGND sg13g2_decap_8
XFILLER_23_111 VPWR VGND sg13g2_decap_8
XFILLER_24_601 VPWR VGND sg13g2_decap_8
XFILLER_28_439 VPWR VGND sg13g2_decap_8
XFILLER_36_472 VPWR VGND sg13g2_decap_8
XFILLER_23_188 VPWR VGND sg13g2_decap_8
XFILLER_11_11 VPWR VGND sg13g2_decap_8
XFILLER_11_88 VPWR VGND sg13g2_decap_8
XFILLER_19_428 VPWR VGND sg13g2_decap_8
XFILLER_46_203 VPWR VGND sg13g2_decap_8
XFILLER_14_111 VPWR VGND sg13g2_decap_8
XFILLER_14_188 VPWR VGND sg13g2_decap_8
XFILLER_15_634 VPWR VGND sg13g2_decap_8
XFILLER_27_461 VPWR VGND sg13g2_decap_8
XFILLER_36_85 VPWR VGND sg13g2_decap_8
XFILLER_42_420 VPWR VGND sg13g2_decap_8
XFILLER_42_497 VPWR VGND sg13g2_decap_8
XFILLER_10_361 VPWR VGND sg13g2_decap_8
XFILLER_7_822 VPWR VGND sg13g2_fill_1
XFILLER_7_811 VPWR VGND sg13g2_decap_8
XFILLER_6_354 VPWR VGND sg13g2_decap_8
XFILLER_2_571 VPWR VGND sg13g2_decap_8
XFILLER_42_7 VPWR VGND sg13g2_decap_8
XFILLER_18_472 VPWR VGND sg13g2_decap_8
XFILLER_37_236 VPWR VGND sg13g2_decap_8
XFILLER_38_726 VPWR VGND sg13g2_decap_8
XFILLER_45_280 VPWR VGND sg13g2_decap_8
XFILLER_20_125 VPWR VGND sg13g2_decap_8
XFILLER_21_604 VPWR VGND sg13g2_decap_8
XFILLER_33_464 VPWR VGND sg13g2_decap_8
X_0936_ net114 VGND VPWR _0096_ daisychain\[32\] clknet_5_1__leaf_clk sg13g2_dfrbpq_1
X_0867_ VPWR _0233_ daisychain\[40\] VGND sg13g2_inv_1
X_0798_ VPWR _0060_ state\[6\] VGND sg13g2_inv_1
XFILLER_28_236 VPWR VGND sg13g2_decap_8
XFILLER_24_486 VPWR VGND sg13g2_decap_8
XFILLER_24_497 VPWR VGND sg13g2_fill_2
XFILLER_43_217 VPWR VGND sg13g2_decap_8
XFILLER_11_158 VPWR VGND sg13g2_decap_8
XFILLER_12_648 VPWR VGND sg13g2_decap_4
XFILLER_22_76 VPWR VGND sg13g2_decap_8
XFILLER_4_814 VPWR VGND sg13g2_decap_8
XFILLER_3_368 VPWR VGND sg13g2_decap_8
XFILLER_15_420 VPWR VGND sg13g2_decap_8
XFILLER_19_225 VPWR VGND sg13g2_decap_8
XFILLER_34_217 VPWR VGND sg13g2_decap_8
XFILLER_47_567 VPWR VGND sg13g2_decap_8
XFILLER_47_84 VPWR VGND sg13g2_decap_8
XFILLER_15_497 VPWR VGND sg13g2_decap_8
XFILLER_30_445 VPWR VGND sg13g2_decap_8
XFILLER_42_294 VPWR VGND sg13g2_decap_8
Xclkbuf_5_21__f_clk clknet_5_21__leaf_clk clknet_4_10_0_clk VPWR VGND sg13g2_buf_16
XFILLER_8_56 VPWR VGND sg13g2_decap_8
X_0721_ _0262_ VPWR _0129_ VGND net82 _0043_ sg13g2_o21ai_1
X_0652_ _0240_ net74 _0399_ _0400_ VPWR VGND sg13g2_a21o_1
X_0583_ net85 VPWR _0348_ VGND net62 state\[30\] sg13g2_o21ai_1
XFILLER_6_151 VPWR VGND sg13g2_decap_8
XFILLER_38_523 VPWR VGND sg13g2_decap_8
XFILLER_25_228 VPWR VGND sg13g2_decap_8
XFILLER_33_261 VPWR VGND sg13g2_decap_8
Xdigitalen.g\[0\].u.inv1 VPWR digitalen.g\[0\].u.OUTN net6 VGND sg13g2_inv_1
XFILLER_21_423 VPWR VGND sg13g2_decap_8
X_0919_ net108 VGND VPWR _0079_ daisychain\[15\] clknet_5_17__leaf_clk sg13g2_dfrbpq_1
XFILLER_16_217 VPWR VGND sg13g2_decap_8
XFILLER_29_534 VPWR VGND sg13g2_decap_8
XFILLER_44_504 VPWR VGND sg13g2_decap_8
XFILLER_12_445 VPWR VGND sg13g2_decap_8
XFILLER_17_87 VPWR VGND sg13g2_decap_8
XFILLER_24_261 VPWR VGND sg13g2_decap_8
XFILLER_33_86 VPWR VGND sg13g2_decap_8
XFILLER_8_427 VPWR VGND sg13g2_decap_8
XFILLER_4_655 VPWR VGND sg13g2_decap_8
XFILLER_3_165 VPWR VGND sg13g2_decap_8
XFILLER_22_209 VPWR VGND sg13g2_decap_8
XFILLER_35_559 VPWR VGND sg13g2_decap_8
XFILLER_47_364 VPWR VGND sg13g2_decap_8
XFILLER_15_294 VPWR VGND sg13g2_decap_8
XFILLER_30_242 VPWR VGND sg13g2_decap_8
XFILLER_43_581 VPWR VGND sg13g2_decap_8
X_0704_ _0253_ net57 _0438_ _0439_ VPWR VGND sg13g2_a21o_1
X_0635_ net95 VPWR _0387_ VGND net73 state\[43\] sg13g2_o21ai_1
X_0566_ _0089_ _0334_ _0335_ net38 _0218_ VPWR VGND sg13g2_a22oi_1
XFILLER_26_504 VPWR VGND sg13g2_decap_8
XFILLER_38_364 VPWR VGND sg13g2_decap_8
XFILLER_38_375 VPWR VGND sg13g2_fill_2
X_0497_ VGND VPWR net25 daisychain\[7\] _0284_ net42 sg13g2_a21oi_1
XFILLER_13_209 VPWR VGND sg13g2_decap_8
XFILLER_21_220 VPWR VGND sg13g2_decap_8
XFILLER_22_776 VPWR VGND sg13g2_fill_2
XFILLER_22_787 VPWR VGND sg13g2_fill_1
XFILLER_34_581 VPWR VGND sg13g2_decap_4
XFILLER_41_518 VPWR VGND sg13g2_decap_8
X_1049_ daisychain\[57\] net16 VPWR VGND sg13g2_buf_1
XFILLER_21_297 VPWR VGND sg13g2_decap_8
XFILLER_0_168 VPWR VGND sg13g2_decap_8
XFILLER_1_658 VPWR VGND sg13g2_decap_8
XFILLER_29_320 VPWR VGND sg13g2_decap_8
XFILLER_13_710 VPWR VGND sg13g2_fill_2
XFILLER_28_75 VPWR VGND sg13g2_decap_8
XFILLER_29_397 VPWR VGND sg13g2_decap_8
XFILLER_32_529 VPWR VGND sg13g2_decap_8
XFILLER_44_301 VPWR VGND sg13g2_decap_8
XFILLER_44_378 VPWR VGND sg13g2_decap_8
XFILLER_12_242 VPWR VGND sg13g2_decap_8
XFILLER_13_743 VPWR VGND sg13g2_fill_1
XFILLER_25_592 VPWR VGND sg13g2_decap_8
XFILLER_40_595 VPWR VGND sg13g2_decap_8
XFILLER_44_63 VPWR VGND sg13g2_decap_8
XFILLER_8_224 VPWR VGND sg13g2_decap_8
XFILLER_5_46 VPWR VGND sg13g2_decap_8
XFILLER_4_452 VPWR VGND sg13g2_decap_8
XFILLER_47_161 VPWR VGND sg13g2_decap_8
XFILLER_48_651 VPWR VGND sg13g2_decap_8
XFILLER_16_581 VPWR VGND sg13g2_decap_8
XFILLER_35_356 VPWR VGND sg13g2_decap_8
X_0618_ _0102_ _0373_ _0374_ net47 _0231_ VPWR VGND sg13g2_a22oi_1
X_0549_ VGND VPWR net26 daisychain\[20\] _0323_ net43 sg13g2_a21oi_1
XFILLER_26_301 VPWR VGND sg13g2_decap_8
XFILLER_26_378 VPWR VGND sg13g2_decap_8
XFILLER_38_161 VPWR VGND sg13g2_decap_8
XFILLER_41_315 VPWR VGND sg13g2_decap_8
XFILLER_14_55 VPWR VGND sg13g2_decap_8
XFILLER_22_573 VPWR VGND sg13g2_decap_8
XFILLER_30_32 VPWR VGND sg13g2_decap_8
XFILLER_5_249 VPWR VGND sg13g2_decap_8
XFILLER_18_813 VPWR VGND sg13g2_decap_8
XFILLER_1_455 VPWR VGND sg13g2_decap_8
XFILLER_39_63 VPWR VGND sg13g2_decap_8
XFILLER_49_459 VPWR VGND sg13g2_decap_8
XFILLER_17_367 VPWR VGND sg13g2_decap_8
XFILLER_29_194 VPWR VGND sg13g2_decap_8
XFILLER_32_326 VPWR VGND sg13g2_decap_8
XFILLER_44_175 VPWR VGND sg13g2_decap_8
XFILLER_45_665 VPWR VGND sg13g2_decap_8
XFILLER_40_392 VPWR VGND sg13g2_decap_8
XFILLER_9_522 VPWR VGND sg13g2_decap_8
XFILLER_35_153 VPWR VGND sg13g2_decap_8
XFILLER_36_687 VPWR VGND sg13g2_decap_8
XFILLER_26_175 VPWR VGND sg13g2_decap_8
XFILLER_27_643 VPWR VGND sg13g2_fill_2
XFILLER_41_112 VPWR VGND sg13g2_decap_8
XFILLER_42_602 VPWR VGND sg13g2_decap_8
Xclkbuf_5_2__f_clk clknet_5_2__leaf_clk clknet_4_1_0_clk VPWR VGND sg13g2_buf_16
XFILLER_10_543 VPWR VGND sg13g2_decap_8
XFILLER_22_370 VPWR VGND sg13g2_decap_8
XFILLER_41_189 VPWR VGND sg13g2_decap_8
XFILLER_41_42 VPWR VGND sg13g2_decap_8
XFILLER_6_536 VPWR VGND sg13g2_decap_8
XFILLER_1_252 VPWR VGND sg13g2_decap_8
XFILLER_2_25 VPWR VGND sg13g2_decap_8
XFILLER_2_764 VPWR VGND sg13g2_fill_1
XFILLER_17_164 VPWR VGND sg13g2_decap_8
XFILLER_37_407 VPWR VGND sg13g2_decap_8
XFILLER_45_462 VPWR VGND sg13g2_decap_8
XFILLER_49_256 VPWR VGND sg13g2_decap_8
XFILLER_13_370 VPWR VGND sg13g2_decap_8
XFILLER_20_307 VPWR VGND sg13g2_decap_8
XFILLER_21_808 VPWR VGND sg13g2_decap_8
XFILLER_32_123 VPWR VGND sg13g2_decap_8
XFILLER_33_635 VPWR VGND sg13g2_fill_1
XFILLER_41_690 VPWR VGND sg13g2_fill_2
X_0952_ net119 VGND VPWR _0112_ daisychain\[48\] clknet_5_13__leaf_clk sg13g2_dfrbpq_1
X_0883_ VPWR _0241_ daisychain\[48\] VGND sg13g2_inv_1
XFILLER_9_396 VPWR VGND sg13g2_decap_8
XFILLER_28_418 VPWR VGND sg13g2_decap_8
XFILLER_24_657 VPWR VGND sg13g2_decap_8
XFILLER_24_679 VPWR VGND sg13g2_fill_1
XFILLER_36_451 VPWR VGND sg13g2_decap_8
XFILLER_23_167 VPWR VGND sg13g2_decap_8
Xclkbuf_4_2_0_clk clknet_0_clk clknet_4_2_0_clk VPWR VGND sg13g2_buf_8
XFILLER_11_67 VPWR VGND sg13g2_decap_8
XFILLER_19_407 VPWR VGND sg13g2_decap_8
XFILLER_27_440 VPWR VGND sg13g2_decap_8
XFILLER_36_64 VPWR VGND sg13g2_decap_8
XFILLER_46_259 VPWR VGND sg13g2_decap_8
XFILLER_14_167 VPWR VGND sg13g2_decap_8
XFILLER_30_616 VPWR VGND sg13g2_fill_2
XFILLER_30_638 VPWR VGND sg13g2_fill_1
XFILLER_42_476 VPWR VGND sg13g2_decap_8
XFILLER_10_340 VPWR VGND sg13g2_decap_8
XFILLER_6_333 VPWR VGND sg13g2_decap_8
XFILLER_2_550 VPWR VGND sg13g2_decap_8
XFILLER_35_7 VPWR VGND sg13g2_fill_2
XFILLER_37_215 VPWR VGND sg13g2_decap_8
XFILLER_18_451 VPWR VGND sg13g2_decap_8
XFILLER_33_443 VPWR VGND sg13g2_decap_8
XFILLER_20_104 VPWR VGND sg13g2_decap_8
XFILLER_21_638 VPWR VGND sg13g2_decap_8
X_0866_ VPWR _0030_ state\[40\] VGND sg13g2_inv_1
X_0935_ net113 VGND VPWR _0095_ daisychain\[31\] clknet_5_3__leaf_clk sg13g2_dfrbpq_1
XFILLER_9_193 VPWR VGND sg13g2_decap_8
X_0797_ VPWR _0198_ daisychain\[5\] VGND sg13g2_inv_1
XFILLER_28_215 VPWR VGND sg13g2_decap_8
XFILLER_11_137 VPWR VGND sg13g2_decap_8
XFILLER_24_465 VPWR VGND sg13g2_decap_8
XFILLER_36_281 VPWR VGND sg13g2_decap_8
XFILLER_20_660 VPWR VGND sg13g2_fill_2
XFILLER_22_11 VPWR VGND sg13g2_decap_8
XFILLER_22_55 VPWR VGND sg13g2_decap_8
XFILLER_7_119 VPWR VGND sg13g2_decap_8
XFILLER_19_204 VPWR VGND sg13g2_decap_8
XFILLER_3_347 VPWR VGND sg13g2_decap_8
XFILLER_47_546 VPWR VGND sg13g2_decap_8
XFILLER_47_63 VPWR VGND sg13g2_decap_8
XFILLER_15_476 VPWR VGND sg13g2_decap_8
XFILLER_30_424 VPWR VGND sg13g2_decap_8
XFILLER_42_273 VPWR VGND sg13g2_decap_8
X_0720_ _0258_ VPWR _0128_ VGND net81 _0032_ sg13g2_o21ai_1
XFILLER_8_35 VPWR VGND sg13g2_decap_8
X_0651_ net96 VPWR _0399_ VGND net74 state\[47\] sg13g2_o21ai_1
X_0582_ _0093_ _0346_ _0347_ net37 _0222_ VPWR VGND sg13g2_a22oi_1
XFILLER_6_130 VPWR VGND sg13g2_decap_8
XFILLER_33_4 VPWR VGND sg13g2_decap_8
XFILLER_21_402 VPWR VGND sg13g2_decap_8
XFILLER_25_207 VPWR VGND sg13g2_decap_8
XFILLER_33_240 VPWR VGND sg13g2_decap_8
Xdigitalen.g\[0\].u.inv2 VPWR digitalen.g\[0\].u.OUTP digitalen.g\[0\].u.OUTN VGND
+ sg13g2_inv_1
XFILLER_21_479 VPWR VGND sg13g2_decap_8
X_0918_ net108 VGND VPWR _0078_ daisychain\[14\] clknet_5_21__leaf_clk sg13g2_dfrbpq_1
X_0849_ VPWR _0224_ daisychain\[31\] VGND sg13g2_inv_1
XFILLER_17_66 VPWR VGND sg13g2_decap_8
XFILLER_12_424 VPWR VGND sg13g2_decap_8
XFILLER_24_240 VPWR VGND sg13g2_decap_8
XFILLER_33_65 VPWR VGND sg13g2_decap_8
XFILLER_40_733 VPWR VGND sg13g2_decap_8
XFILLER_8_406 VPWR VGND sg13g2_decap_8
XFILLER_3_144 VPWR VGND sg13g2_decap_8
XFILLER_4_634 VPWR VGND sg13g2_decap_8
XFILLER_47_343 VPWR VGND sg13g2_decap_8
XFILLER_15_273 VPWR VGND sg13g2_decap_8
XFILLER_30_221 VPWR VGND sg13g2_decap_8
XFILLER_35_538 VPWR VGND sg13g2_decap_8
XFILLER_43_560 VPWR VGND sg13g2_decap_8
XFILLER_30_298 VPWR VGND sg13g2_decap_8
XFILLER_31_799 VPWR VGND sg13g2_decap_8
X_0703_ net80 VPWR _0438_ VGND net57 state\[60\] sg13g2_o21ai_1
XFILLER_7_483 VPWR VGND sg13g2_decap_8
X_0634_ _0106_ _0385_ _0386_ net51 _0235_ VPWR VGND sg13g2_a22oi_1
X_0565_ VGND VPWR net23 daisychain\[24\] _0335_ net38 sg13g2_a21oi_1
X_0496_ _0201_ net64 _0282_ _0283_ VPWR VGND sg13g2_a21o_1
XFILLER_38_343 VPWR VGND sg13g2_decap_8
XFILLER_0_91 VPWR VGND sg13g2_decap_8
XFILLER_21_276 VPWR VGND sg13g2_decap_8
XFILLER_34_560 VPWR VGND sg13g2_decap_8
X_1048_ daisychain\[56\] net15 VPWR VGND sg13g2_buf_1
XFILLER_0_147 VPWR VGND sg13g2_decap_8
XFILLER_1_637 VPWR VGND sg13g2_decap_8
XFILLER_28_54 VPWR VGND sg13g2_decap_8
XFILLER_12_221 VPWR VGND sg13g2_decap_8
XFILLER_17_549 VPWR VGND sg13g2_decap_8
XFILLER_25_571 VPWR VGND sg13g2_decap_8
XFILLER_29_376 VPWR VGND sg13g2_decap_8
XFILLER_32_508 VPWR VGND sg13g2_decap_8
XFILLER_44_357 VPWR VGND sg13g2_decap_8
XFILLER_44_42 VPWR VGND sg13g2_decap_8
XFILLER_12_298 VPWR VGND sg13g2_decap_8
XFILLER_40_574 VPWR VGND sg13g2_decap_8
XFILLER_8_203 VPWR VGND sg13g2_decap_8
XFILLER_5_25 VPWR VGND sg13g2_decap_8
XFILLER_4_431 VPWR VGND sg13g2_decap_8
XFILLER_35_335 VPWR VGND sg13g2_decap_8
XFILLER_47_140 VPWR VGND sg13g2_decap_8
XFILLER_48_630 VPWR VGND sg13g2_decap_8
XFILLER_16_560 VPWR VGND sg13g2_decap_8
XFILLER_31_585 VPWR VGND sg13g2_decap_8
XFILLER_7_280 VPWR VGND sg13g2_decap_8
X_0617_ VGND VPWR net28 daisychain\[37\] _0374_ net47 sg13g2_a21oi_1
X_0548_ _0214_ net66 _0321_ _0322_ VPWR VGND sg13g2_a21o_1
X_0479_ net82 VPWR _0270_ VGND net59 state\[4\] sg13g2_o21ai_1
XFILLER_26_357 VPWR VGND sg13g2_decap_8
XFILLER_38_140 VPWR VGND sg13g2_decap_8
XFILLER_42_806 VPWR VGND sg13g2_fill_2
XFILLER_14_34 VPWR VGND sg13g2_decap_8
XFILLER_22_552 VPWR VGND sg13g2_decap_8
XFILLER_5_228 VPWR VGND sg13g2_decap_8
XFILLER_1_434 VPWR VGND sg13g2_decap_8
XFILLER_30_88 VPWR VGND sg13g2_decap_8
XFILLER_39_42 VPWR VGND sg13g2_decap_8
XFILLER_17_346 VPWR VGND sg13g2_decap_8
XFILLER_29_173 VPWR VGND sg13g2_decap_8
XFILLER_45_644 VPWR VGND sg13g2_decap_8
XFILLER_49_438 VPWR VGND sg13g2_decap_8
XFILLER_13_552 VPWR VGND sg13g2_decap_8
XFILLER_13_563 VPWR VGND sg13g2_fill_1
XFILLER_32_305 VPWR VGND sg13g2_decap_8
XFILLER_40_371 VPWR VGND sg13g2_decap_8
XFILLER_44_154 VPWR VGND sg13g2_decap_8
XFILLER_9_501 VPWR VGND sg13g2_decap_8
XFILLER_9_589 VPWR VGND sg13g2_fill_2
XFILLER_9_578 VPWR VGND sg13g2_decap_8
XFILLER_35_132 VPWR VGND sg13g2_decap_8
XFILLER_36_655 VPWR VGND sg13g2_fill_1
XFILLER_23_349 VPWR VGND sg13g2_decap_8
XFILLER_31_382 VPWR VGND sg13g2_decap_8
XFILLER_27_622 VPWR VGND sg13g2_decap_8
XFILLER_14_349 VPWR VGND sg13g2_decap_8
XFILLER_25_88 VPWR VGND sg13g2_decap_8
XFILLER_26_154 VPWR VGND sg13g2_decap_8
XFILLER_41_168 VPWR VGND sg13g2_decap_8
XFILLER_42_669 VPWR VGND sg13g2_decap_8
XFILLER_10_522 VPWR VGND sg13g2_decap_8
XFILLER_41_21 VPWR VGND sg13g2_decap_8
XFILLER_41_98 VPWR VGND sg13g2_decap_8
XFILLER_6_515 VPWR VGND sg13g2_decap_8
XFILLER_1_231 VPWR VGND sg13g2_decap_8
XFILLER_49_235 VPWR VGND sg13g2_decap_8
XFILLER_17_143 VPWR VGND sg13g2_decap_8
XFILLER_32_102 VPWR VGND sg13g2_decap_8
XFILLER_33_603 VPWR VGND sg13g2_fill_1
XFILLER_45_441 VPWR VGND sg13g2_decap_8
XFILLER_32_179 VPWR VGND sg13g2_decap_8
X_0882_ VPWR _0007_ state\[48\] VGND sg13g2_inv_1
X_0951_ net118 VGND VPWR _0111_ daisychain\[47\] clknet_5_6__leaf_clk sg13g2_dfrbpq_1
XFILLER_9_375 VPWR VGND sg13g2_decap_8
XFILLER_5_592 VPWR VGND sg13g2_decap_8
XFILLER_11_319 VPWR VGND sg13g2_decap_8
XFILLER_23_146 VPWR VGND sg13g2_decap_8
XFILLER_24_636 VPWR VGND sg13g2_decap_8
XFILLER_36_430 VPWR VGND sg13g2_decap_8
XFILLER_11_46 VPWR VGND sg13g2_decap_8
XFILLER_3_529 VPWR VGND sg13g2_decap_8
XFILLER_27_496 VPWR VGND sg13g2_decap_8
XFILLER_46_238 VPWR VGND sg13g2_decap_8
XFILLER_47_728 VPWR VGND sg13g2_decap_8
XFILLER_47_739 VPWR VGND sg13g2_fill_1
XFILLER_14_146 VPWR VGND sg13g2_decap_8
XFILLER_42_455 VPWR VGND sg13g2_decap_8
XFILLER_10_396 VPWR VGND sg13g2_decap_8
XFILLER_6_389 VPWR VGND sg13g2_decap_8
XFILLER_6_312 VPWR VGND sg13g2_decap_8
XFILLER_18_430 VPWR VGND sg13g2_decap_8
XFILLER_21_617 VPWR VGND sg13g2_decap_8
XFILLER_33_422 VPWR VGND sg13g2_decap_8
XFILLER_33_499 VPWR VGND sg13g2_decap_8
X_0865_ VPWR _0232_ daisychain\[39\] VGND sg13g2_inv_1
X_0934_ net105 VGND VPWR _0094_ daisychain\[30\] clknet_5_27__leaf_clk sg13g2_dfrbpq_1
XFILLER_9_172 VPWR VGND sg13g2_decap_8
X_0796_ VPWR _0059_ state\[5\] VGND sg13g2_inv_1
XFILLER_36_260 VPWR VGND sg13g2_decap_8
XFILLER_11_116 VPWR VGND sg13g2_decap_8
XFILLER_22_34 VPWR VGND sg13g2_decap_8
XFILLER_24_444 VPWR VGND sg13g2_decap_8
XFILLER_20_694 VPWR VGND sg13g2_fill_1
XFILLER_3_326 VPWR VGND sg13g2_decap_8
XFILLER_47_42 VPWR VGND sg13g2_decap_8
XFILLER_47_525 VPWR VGND sg13g2_decap_8
XFILLER_15_455 VPWR VGND sg13g2_decap_8
XFILLER_27_293 VPWR VGND sg13g2_decap_8
XFILLER_30_403 VPWR VGND sg13g2_decap_8
XFILLER_42_252 VPWR VGND sg13g2_decap_8
XFILLER_10_193 VPWR VGND sg13g2_decap_8
XFILLER_8_14 VPWR VGND sg13g2_decap_8
Xdac0 digitalen.g\[1\].u.OUTP digitalen.g\[1\].u.OUTN digitalen.g\[2\].u.OUTP digitalen.g\[2\].u.OUTN
+ state\[16\] _0039_ state\[17\] _0040_ state\[18\] _0041_ state\[19\] _0042_ state\[20\]
+ _0044_ state\[21\] _0045_ state\[22\] _0046_ state\[23\] _0047_ state\[24\] _0048_
+ state\[25\] _0049_ state\[26\] _0050_ state\[27\] _0051_ state\[28\] _0052_ state\[29\]
+ _0053_ state\[30\] _0055_ state\[31\] _0056_ digitalen.g\[3\].u.OUTP digitalen.g\[3\].u.OUTN
+ state\[0\] _0032_ state\[1\] _0043_ state\[2\] _0054_ state\[3\] _0057_ state\[4\]
+ _0058_ state\[5\] _0059_ state\[6\] digitalen.g\[0\].u.OUTP digitalen.g\[0\].u.OUTN
+ _0060_ state\[7\] _0061_ state\[8\] _0062_ state\[9\] _0063_ state\[10\] _0033_
+ state\[11\] _0034_ state\[12\] _0035_ state\[13\] _0036_ state\[14\] _0037_ state\[15\]
+ _0038_ dac0/Iout dac0/VbiasP[0] dac0/VbiasP[1] dac0/VcascP[1] dac0/VcascP[0] VPWR
+ VGND dac32module
X_0650_ _0110_ _0397_ _0398_ net51 _0239_ VPWR VGND sg13g2_a22oi_1
X_0581_ VGND VPWR net24 daisychain\[28\] _0347_ net37 sg13g2_a21oi_1
XFILLER_6_186 VPWR VGND sg13g2_decap_8
XFILLER_19_794 VPWR VGND sg13g2_decap_4
XFILLER_26_4 VPWR VGND sg13g2_decap_4
XFILLER_38_558 VPWR VGND sg13g2_fill_1
Xclkbuf_4_1_0_clk clknet_0_clk clknet_4_1_0_clk VPWR VGND sg13g2_buf_8
XFILLER_21_458 VPWR VGND sg13g2_decap_8
XFILLER_33_296 VPWR VGND sg13g2_decap_8
X_0917_ net108 VGND VPWR _0077_ daisychain\[13\] clknet_5_17__leaf_clk sg13g2_dfrbpq_1
X_0848_ VPWR _0056_ state\[31\] VGND sg13g2_inv_1
X_0779_ _0436_ VPWR _0187_ VGND net81 _0019_ sg13g2_o21ai_1
XFILLER_0_329 VPWR VGND sg13g2_decap_8
XFILLER_12_403 VPWR VGND sg13g2_decap_8
XFILLER_25_775 VPWR VGND sg13g2_decap_8
XFILLER_29_569 VPWR VGND sg13g2_decap_4
XFILLER_44_539 VPWR VGND sg13g2_decap_8
XFILLER_24_296 VPWR VGND sg13g2_decap_8
XFILLER_33_11 VPWR VGND sg13g2_decap_8
XFILLER_33_44 VPWR VGND sg13g2_decap_8
XFILLER_3_123 VPWR VGND sg13g2_decap_8
XFILLER_4_613 VPWR VGND sg13g2_decap_8
XFILLER_35_517 VPWR VGND sg13g2_decap_8
XFILLER_47_322 VPWR VGND sg13g2_decap_8
XFILLER_48_812 VPWR VGND sg13g2_decap_8
XFILLER_15_252 VPWR VGND sg13g2_decap_8
XFILLER_30_200 VPWR VGND sg13g2_decap_8
XFILLER_47_399 VPWR VGND sg13g2_decap_8
XFILLER_11_480 VPWR VGND sg13g2_decap_8
XFILLER_30_277 VPWR VGND sg13g2_decap_8
X_0702_ _0123_ _0436_ _0437_ net34 _0252_ VPWR VGND sg13g2_a22oi_1
X_0633_ VGND VPWR net29 daisychain\[41\] _0386_ net50 sg13g2_a21oi_1
XFILLER_7_462 VPWR VGND sg13g2_decap_8
XFILLER_38_322 VPWR VGND sg13g2_decap_8
X_0564_ _0218_ net62 _0333_ _0334_ VPWR VGND sg13g2_a21o_1
X_0495_ net87 VPWR _0282_ VGND net64 state\[8\] sg13g2_o21ai_1
XFILLER_0_70 VPWR VGND sg13g2_decap_8
XFILLER_17_0 VPWR VGND sg13g2_fill_2
XFILLER_26_539 VPWR VGND sg13g2_decap_8
XFILLER_38_388 VPWR VGND sg13g2_decap_8
X_1047_ state\[63\] net14 VPWR VGND sg13g2_buf_1
XFILLER_21_255 VPWR VGND sg13g2_decap_8
XFILLER_22_778 VPWR VGND sg13g2_fill_1
XFILLER_0_126 VPWR VGND sg13g2_decap_8
XFILLER_1_616 VPWR VGND sg13g2_decap_8
XFILLER_17_528 VPWR VGND sg13g2_decap_8
XFILLER_28_33 VPWR VGND sg13g2_decap_8
XFILLER_29_355 VPWR VGND sg13g2_decap_8
XFILLER_48_119 VPWR VGND sg13g2_decap_8
XFILLER_12_200 VPWR VGND sg13g2_decap_8
XFILLER_13_712 VPWR VGND sg13g2_fill_1
XFILLER_25_550 VPWR VGND sg13g2_decap_8
XFILLER_40_553 VPWR VGND sg13g2_decap_8
XFILLER_44_21 VPWR VGND sg13g2_decap_8
XFILLER_44_336 VPWR VGND sg13g2_decap_8
XFILLER_44_98 VPWR VGND sg13g2_decap_8
XFILLER_12_277 VPWR VGND sg13g2_decap_8
XFILLER_8_259 VPWR VGND sg13g2_decap_8
XFILLER_4_410 VPWR VGND sg13g2_decap_8
XFILLER_39_119 VPWR VGND sg13g2_decap_8
XFILLER_4_487 VPWR VGND sg13g2_decap_8
XFILLER_0_693 VPWR VGND sg13g2_decap_8
XFILLER_35_314 VPWR VGND sg13g2_decap_8
XFILLER_47_196 VPWR VGND sg13g2_decap_8
XFILLER_48_686 VPWR VGND sg13g2_decap_8
XFILLER_31_564 VPWR VGND sg13g2_decap_8
X_0616_ _0231_ net71 _0372_ _0373_ VPWR VGND sg13g2_a21o_1
X_0547_ net89 VPWR _0321_ VGND net66 state\[21\] sg13g2_o21ai_1
X_0478_ _0067_ _0268_ _0269_ net36 _0196_ VPWR VGND sg13g2_a22oi_1
XFILLER_14_13 VPWR VGND sg13g2_decap_8
XFILLER_22_531 VPWR VGND sg13g2_decap_8
XFILLER_26_336 VPWR VGND sg13g2_decap_8
XFILLER_38_196 VPWR VGND sg13g2_decap_8
XFILLER_30_23 VPWR VGND sg13g2_fill_1
XFILLER_5_207 VPWR VGND sg13g2_decap_8
XFILLER_1_413 VPWR VGND sg13g2_decap_8
XFILLER_30_67 VPWR VGND sg13g2_decap_8
XFILLER_39_21 VPWR VGND sg13g2_decap_8
XFILLER_49_417 VPWR VGND sg13g2_decap_8
XFILLER_17_325 VPWR VGND sg13g2_decap_8
XFILLER_29_152 VPWR VGND sg13g2_decap_8
XFILLER_39_98 VPWR VGND sg13g2_decap_8
XFILLER_44_133 VPWR VGND sg13g2_decap_8
XFILLER_45_623 VPWR VGND sg13g2_decap_8
XFILLER_13_531 VPWR VGND sg13g2_decap_8
XFILLER_40_350 VPWR VGND sg13g2_decap_8
XFILLER_9_557 VPWR VGND sg13g2_decap_8
XFILLER_4_284 VPWR VGND sg13g2_decap_8
XFILLER_0_490 VPWR VGND sg13g2_decap_8
Xclkbuf_5_27__f_clk clknet_5_27__leaf_clk clknet_4_13_0_clk VPWR VGND sg13g2_buf_16
XFILLER_23_328 VPWR VGND sg13g2_decap_8
XFILLER_35_111 VPWR VGND sg13g2_decap_8
XFILLER_35_188 VPWR VGND sg13g2_decap_8
XFILLER_36_667 VPWR VGND sg13g2_decap_8
XFILLER_48_483 VPWR VGND sg13g2_decap_8
XFILLER_31_361 VPWR VGND sg13g2_decap_8
XFILLER_26_133 VPWR VGND sg13g2_decap_8
XFILLER_27_601 VPWR VGND sg13g2_decap_8
XFILLER_27_645 VPWR VGND sg13g2_fill_1
XFILLER_10_501 VPWR VGND sg13g2_decap_8
XFILLER_14_328 VPWR VGND sg13g2_decap_8
XFILLER_25_67 VPWR VGND sg13g2_decap_8
XFILLER_41_147 VPWR VGND sg13g2_decap_8
XFILLER_42_637 VPWR VGND sg13g2_fill_2
XFILLER_1_210 VPWR VGND sg13g2_decap_8
XFILLER_41_77 VPWR VGND sg13g2_decap_8
XFILLER_1_287 VPWR VGND sg13g2_decap_8
XFILLER_2_755 VPWR VGND sg13g2_decap_8
XFILLER_49_214 VPWR VGND sg13g2_decap_8
XFILLER_17_122 VPWR VGND sg13g2_decap_8
XFILLER_17_199 VPWR VGND sg13g2_decap_8
XFILLER_45_420 VPWR VGND sg13g2_decap_8
XFILLER_45_497 VPWR VGND sg13g2_decap_8
XFILLER_32_158 VPWR VGND sg13g2_decap_8
X_0881_ VPWR _0240_ daisychain\[47\] VGND sg13g2_inv_1
X_0950_ net118 VGND VPWR _0110_ daisychain\[46\] clknet_5_7__leaf_clk sg13g2_dfrbpq_1
XFILLER_9_354 VPWR VGND sg13g2_decap_8
XFILLER_5_571 VPWR VGND sg13g2_decap_8
XFILLER_48_280 VPWR VGND sg13g2_decap_8
XFILLER_49_781 VPWR VGND sg13g2_decap_8
XFILLER_23_125 VPWR VGND sg13g2_decap_8
XFILLER_24_615 VPWR VGND sg13g2_decap_8
XFILLER_36_486 VPWR VGND sg13g2_decap_8
XFILLER_11_25 VPWR VGND sg13g2_decap_8
XFILLER_3_508 VPWR VGND sg13g2_decap_8
XFILLER_47_707 VPWR VGND sg13g2_decap_8
Xclkbuf_5_10__f_clk clknet_5_10__leaf_clk clknet_4_5_0_clk VPWR VGND sg13g2_buf_16
XFILLER_14_125 VPWR VGND sg13g2_decap_8
XFILLER_27_475 VPWR VGND sg13g2_decap_8
XFILLER_36_99 VPWR VGND sg13g2_decap_8
XFILLER_39_280 VPWR VGND sg13g2_decap_8
XFILLER_42_434 VPWR VGND sg13g2_decap_8
XFILLER_46_217 VPWR VGND sg13g2_decap_8
XFILLER_10_375 VPWR VGND sg13g2_decap_8
XFILLER_30_618 VPWR VGND sg13g2_fill_1
XFILLER_6_368 VPWR VGND sg13g2_decap_8
XFILLER_2_585 VPWR VGND sg13g2_decap_8
XFILLER_46_762 VPWR VGND sg13g2_fill_1
XFILLER_18_486 VPWR VGND sg13g2_decap_8
XFILLER_20_139 VPWR VGND sg13g2_decap_8
XFILLER_33_401 VPWR VGND sg13g2_decap_8
XFILLER_33_478 VPWR VGND sg13g2_decap_8
XFILLER_45_294 VPWR VGND sg13g2_decap_8
X_0864_ VPWR _0029_ state\[39\] VGND sg13g2_inv_1
X_0933_ net106 VGND VPWR _0093_ daisychain\[29\] clknet_5_27__leaf_clk sg13g2_dfrbpq_1
X_0795_ VPWR _0197_ daisychain\[4\] VGND sg13g2_inv_1
XFILLER_9_151 VPWR VGND sg13g2_decap_8
XFILLER_29_729 VPWR VGND sg13g2_decap_8
XFILLER_3_81 VPWR VGND sg13g2_decap_8
XFILLER_47_0 VPWR VGND sg13g2_decap_8
XFILLER_24_401 VPWR VGND sg13g2_decap_8
XFILLER_3_305 VPWR VGND sg13g2_decap_8
XFILLER_19_239 VPWR VGND sg13g2_decap_8
XFILLER_28_751 VPWR VGND sg13g2_decap_4
XFILLER_47_21 VPWR VGND sg13g2_decap_8
XFILLER_47_504 VPWR VGND sg13g2_decap_8
XFILLER_47_98 VPWR VGND sg13g2_decap_8
XFILLER_15_434 VPWR VGND sg13g2_decap_8
XFILLER_27_272 VPWR VGND sg13g2_decap_8
XFILLER_28_795 VPWR VGND sg13g2_decap_4
XFILLER_42_231 VPWR VGND sg13g2_decap_8
XFILLER_43_787 VPWR VGND sg13g2_fill_2
XFILLER_10_172 VPWR VGND sg13g2_decap_8
XFILLER_30_459 VPWR VGND sg13g2_decap_8
Xdac1 digitalen.g\[1\].u.OUTP digitalen.g\[1\].u.OUTN digitalen.g\[2\].u.OUTP digitalen.g\[2\].u.OUTN
+ state\[48\] _0007_ state\[49\] _0008_ state\[50\] _0009_ state\[51\] _0010_ state\[52\]
+ _0012_ state\[53\] _0013_ state\[54\] _0014_ state\[55\] _0015_ state\[56\] _0016_
+ state\[57\] _0017_ state\[58\] _0018_ state\[59\] _0019_ state\[60\] _0020_ state\[61\]
+ _0021_ state\[62\] _0023_ state\[63\] _0024_ digitalen.g\[3\].u.OUTP digitalen.g\[3\].u.OUTN
+ state\[32\] _0000_ state\[33\] _0011_ state\[34\] _0022_ state\[35\] _0025_ state\[36\]
+ _0026_ state\[37\] _0027_ state\[38\] digitalen.g\[0\].u.OUTP digitalen.g\[0\].u.OUTN
+ _0028_ state\[39\] _0029_ state\[40\] _0030_ state\[41\] _0031_ state\[42\] _0001_
+ state\[43\] _0002_ state\[44\] _0003_ state\[45\] _0004_ state\[46\] _0005_ state\[47\]
+ _0006_ dac1/Iout dac1/VbiasP[0] dac1/VbiasP[1] dac1/VcascP[1] dac1/VcascP[0] VPWR
+ VGND dac32module
XFILLER_6_165 VPWR VGND sg13g2_decap_8
XFILLER_2_382 VPWR VGND sg13g2_decap_8
XFILLER_40_7 VPWR VGND sg13g2_decap_8
X_0580_ _0222_ net61 _0345_ _0346_ VPWR VGND sg13g2_a21o_1
XFILLER_18_283 VPWR VGND sg13g2_decap_8
XFILLER_34_710 VPWR VGND sg13g2_fill_2
XFILLER_34_743 VPWR VGND sg13g2_fill_1
XFILLER_38_537 VPWR VGND sg13g2_decap_4
XFILLER_46_581 VPWR VGND sg13g2_decap_8
XFILLER_21_437 VPWR VGND sg13g2_decap_8
XFILLER_33_275 VPWR VGND sg13g2_decap_8
X_0916_ net108 VGND VPWR _0076_ daisychain\[12\] clknet_5_16__leaf_clk sg13g2_dfrbpq_1
XFILLER_0_308 VPWR VGND sg13g2_decap_8
X_0847_ VPWR _0223_ daisychain\[30\] VGND sg13g2_inv_1
X_0778_ _0433_ VPWR _0186_ VGND net81 _0018_ sg13g2_o21ai_1
XFILLER_29_548 VPWR VGND sg13g2_decap_8
XFILLER_24_275 VPWR VGND sg13g2_decap_8
XFILLER_25_743 VPWR VGND sg13g2_fill_1
XFILLER_44_518 VPWR VGND sg13g2_decap_8
XFILLER_12_459 VPWR VGND sg13g2_decap_8
XFILLER_3_102 VPWR VGND sg13g2_decap_8
XFILLER_3_179 VPWR VGND sg13g2_decap_8
Xclkbuf_5_8__f_clk clknet_5_8__leaf_clk clknet_4_4_0_clk VPWR VGND sg13g2_buf_16
XFILLER_4_669 VPWR VGND sg13g2_decap_8
XFILLER_47_301 VPWR VGND sg13g2_decap_8
XFILLER_47_378 VPWR VGND sg13g2_decap_8
XFILLER_15_231 VPWR VGND sg13g2_decap_8
XFILLER_30_256 VPWR VGND sg13g2_decap_8
XFILLER_43_595 VPWR VGND sg13g2_decap_8
X_0701_ VGND VPWR net32 daisychain\[58\] _0437_ net33 sg13g2_a21oi_1
X_0632_ _0235_ net73 _0384_ _0385_ VPWR VGND sg13g2_a21o_1
X_0563_ net84 VPWR _0333_ VGND net62 state\[25\] sg13g2_o21ai_1
XFILLER_7_441 VPWR VGND sg13g2_decap_8
XFILLER_38_301 VPWR VGND sg13g2_decap_8
X_0494_ _0071_ _0280_ _0281_ net42 _0200_ VPWR VGND sg13g2_a22oi_1
XFILLER_19_592 VPWR VGND sg13g2_decap_4
XFILLER_22_702 VPWR VGND sg13g2_fill_2
XFILLER_26_518 VPWR VGND sg13g2_decap_8
X_1046_ state\[62\] net13 VPWR VGND sg13g2_buf_1
XFILLER_21_234 VPWR VGND sg13g2_decap_8
XFILLER_0_105 VPWR VGND sg13g2_decap_8
XFILLER_17_507 VPWR VGND sg13g2_decap_8
XFILLER_28_89 VPWR VGND sg13g2_decap_8
XFILLER_29_334 VPWR VGND sg13g2_decap_8
XFILLER_44_315 VPWR VGND sg13g2_decap_8
XFILLER_12_256 VPWR VGND sg13g2_decap_8
XFILLER_40_532 VPWR VGND sg13g2_decap_8
XFILLER_44_77 VPWR VGND sg13g2_decap_8
XFILLER_9_717 VPWR VGND sg13g2_fill_1
XFILLER_21_790 VPWR VGND sg13g2_decap_8
Xclkbuf_4_0_0_clk clknet_0_clk clknet_4_0_0_clk VPWR VGND sg13g2_buf_8
XFILLER_8_238 VPWR VGND sg13g2_decap_8
XFILLER_4_466 VPWR VGND sg13g2_decap_8
XFILLER_0_672 VPWR VGND sg13g2_decap_8
XFILLER_47_175 VPWR VGND sg13g2_decap_8
XFILLER_48_665 VPWR VGND sg13g2_decap_8
XFILLER_16_595 VPWR VGND sg13g2_decap_8
XFILLER_31_543 VPWR VGND sg13g2_decap_8
XFILLER_43_392 VPWR VGND sg13g2_decap_8
XFILLER_8_783 VPWR VGND sg13g2_fill_2
XFILLER_8_772 VPWR VGND sg13g2_fill_2
X_0615_ net92 VPWR _0372_ VGND net70 state\[38\] sg13g2_o21ai_1
X_0546_ _0084_ _0319_ _0320_ net43 _0213_ VPWR VGND sg13g2_a22oi_1
XFILLER_26_315 VPWR VGND sg13g2_decap_8
XFILLER_38_175 VPWR VGND sg13g2_decap_8
XFILLER_39_698 VPWR VGND sg13g2_fill_1
X_0477_ VGND VPWR net23 daisychain\[2\] _0269_ net36 sg13g2_a21oi_1
XFILLER_14_69 VPWR VGND sg13g2_decap_8
XFILLER_22_510 VPWR VGND sg13g2_decap_8
XFILLER_22_587 VPWR VGND sg13g2_decap_8
XFILLER_34_392 VPWR VGND sg13g2_decap_8
XFILLER_41_329 VPWR VGND sg13g2_decap_8
XFILLER_42_808 VPWR VGND sg13g2_fill_1
XFILLER_42_819 VPWR VGND sg13g2_decap_4
X_1029_ net102 VGND VPWR _0189_ state\[61\] clknet_5_0__leaf_clk sg13g2_dfrbpq_1
XFILLER_30_46 VPWR VGND sg13g2_decap_8
XFILLER_1_469 VPWR VGND sg13g2_decap_8
XFILLER_39_77 VPWR VGND sg13g2_decap_8
XFILLER_13_510 VPWR VGND sg13g2_decap_8
XFILLER_17_304 VPWR VGND sg13g2_decap_8
XFILLER_29_131 VPWR VGND sg13g2_decap_8
XFILLER_44_112 VPWR VGND sg13g2_decap_8
XFILLER_44_189 VPWR VGND sg13g2_decap_8
XFILLER_45_602 VPWR VGND sg13g2_decap_8
XFILLER_45_679 VPWR VGND sg13g2_decap_8
XFILLER_13_576 VPWR VGND sg13g2_decap_8
XFILLER_9_536 VPWR VGND sg13g2_decap_8
XFILLER_20_90 VPWR VGND sg13g2_decap_8
XFILLER_5_775 VPWR VGND sg13g2_decap_8
XFILLER_4_263 VPWR VGND sg13g2_decap_8
XFILLER_48_462 VPWR VGND sg13g2_decap_8
XFILLER_16_392 VPWR VGND sg13g2_decap_8
XFILLER_23_307 VPWR VGND sg13g2_decap_8
XFILLER_24_819 VPWR VGND sg13g2_decap_4
XFILLER_31_340 VPWR VGND sg13g2_decap_8
XFILLER_35_167 VPWR VGND sg13g2_decap_8
X_0529_ VGND VPWR net26 daisychain\[15\] _0308_ net42 sg13g2_a21oi_1
XFILLER_6_81 VPWR VGND sg13g2_decap_8
XFILLER_14_307 VPWR VGND sg13g2_decap_8
XFILLER_26_112 VPWR VGND sg13g2_decap_8
XFILLER_26_189 VPWR VGND sg13g2_decap_8
XFILLER_39_462 VPWR VGND sg13g2_decap_8
XFILLER_42_616 VPWR VGND sg13g2_decap_8
XFILLER_10_557 VPWR VGND sg13g2_decap_8
XFILLER_22_384 VPWR VGND sg13g2_decap_8
XFILLER_25_46 VPWR VGND sg13g2_decap_8
XFILLER_41_126 VPWR VGND sg13g2_decap_8
XFILLER_41_56 VPWR VGND sg13g2_decap_8
XFILLER_17_101 VPWR VGND sg13g2_decap_8
XFILLER_18_635 VPWR VGND sg13g2_decap_8
XFILLER_1_266 VPWR VGND sg13g2_decap_8
XFILLER_2_39 VPWR VGND sg13g2_decap_8
XFILLER_2_778 VPWR VGND sg13g2_decap_8
XFILLER_17_178 VPWR VGND sg13g2_decap_8
XFILLER_32_137 VPWR VGND sg13g2_decap_8
XFILLER_45_476 VPWR VGND sg13g2_decap_8
XFILLER_13_384 VPWR VGND sg13g2_decap_8
X_0880_ VPWR _0006_ state\[47\] VGND sg13g2_inv_1
XFILLER_9_333 VPWR VGND sg13g2_decap_8
XFILLER_5_550 VPWR VGND sg13g2_decap_8
XFILLER_49_4 VPWR VGND sg13g2_decap_8
XFILLER_23_104 VPWR VGND sg13g2_decap_8
XFILLER_36_465 VPWR VGND sg13g2_decap_8
XFILLER_49_760 VPWR VGND sg13g2_decap_8
XFILLER_17_690 VPWR VGND sg13g2_fill_2
Xdigitalen.g\[3\].u.inv1 VPWR digitalen.g\[3\].u.OUTN net6 VGND sg13g2_inv_1
XFILLER_14_104 VPWR VGND sg13g2_decap_8
XFILLER_27_454 VPWR VGND sg13g2_decap_8
XFILLER_36_78 VPWR VGND sg13g2_decap_8
XFILLER_42_413 VPWR VGND sg13g2_decap_8
XFILLER_10_354 VPWR VGND sg13g2_decap_8
XFILLER_22_181 VPWR VGND sg13g2_decap_8
XFILLER_6_347 VPWR VGND sg13g2_decap_8
XFILLER_2_564 VPWR VGND sg13g2_decap_8
XFILLER_7_0 VPWR VGND sg13g2_decap_8
XFILLER_18_465 VPWR VGND sg13g2_decap_8
XFILLER_37_229 VPWR VGND sg13g2_decap_8
XFILLER_38_719 VPWR VGND sg13g2_decap_8
XFILLER_13_181 VPWR VGND sg13g2_decap_8
XFILLER_20_118 VPWR VGND sg13g2_decap_8
XFILLER_33_457 VPWR VGND sg13g2_decap_8
XFILLER_41_490 VPWR VGND sg13g2_decap_8
XFILLER_45_273 VPWR VGND sg13g2_decap_8
X_0932_ net106 VGND VPWR _0092_ daisychain\[28\] clknet_5_26__leaf_clk sg13g2_dfrbpq_1
XFILLER_9_130 VPWR VGND sg13g2_decap_8
X_0863_ VPWR _0231_ daisychain\[38\] VGND sg13g2_inv_1
X_0794_ VPWR _0058_ state\[4\] VGND sg13g2_inv_1
XFILLER_28_229 VPWR VGND sg13g2_decap_8
XFILLER_3_60 VPWR VGND sg13g2_decap_8
XFILLER_24_479 VPWR VGND sg13g2_decap_8
XFILLER_36_295 VPWR VGND sg13g2_decap_8
XFILLER_22_69 VPWR VGND sg13g2_decap_8
XFILLER_4_807 VPWR VGND sg13g2_decap_8
XFILLER_0_7 VPWR VGND sg13g2_decap_8
Xfanout120 net121 net120 VPWR VGND sg13g2_buf_1
XFILLER_19_218 VPWR VGND sg13g2_decap_8
XFILLER_27_251 VPWR VGND sg13g2_decap_8
XFILLER_47_77 VPWR VGND sg13g2_decap_8
XFILLER_15_413 VPWR VGND sg13g2_decap_8
XFILLER_30_438 VPWR VGND sg13g2_decap_8
XFILLER_42_210 VPWR VGND sg13g2_decap_8
XFILLER_42_287 VPWR VGND sg13g2_decap_8
XFILLER_8_49 VPWR VGND sg13g2_decap_8
XFILLER_10_151 VPWR VGND sg13g2_decap_8
XFILLER_6_144 VPWR VGND sg13g2_decap_8
XFILLER_2_361 VPWR VGND sg13g2_decap_8
XFILLER_38_516 VPWR VGND sg13g2_fill_2
XFILLER_18_262 VPWR VGND sg13g2_decap_8
XFILLER_19_741 VPWR VGND sg13g2_fill_2
XFILLER_19_774 VPWR VGND sg13g2_fill_2
XFILLER_33_254 VPWR VGND sg13g2_decap_8
XFILLER_46_560 VPWR VGND sg13g2_decap_8
XFILLER_21_416 VPWR VGND sg13g2_decap_8
X_0915_ net107 VGND VPWR _0075_ daisychain\[11\] clknet_5_16__leaf_clk sg13g2_dfrbpq_1
X_0846_ VPWR _0055_ state\[30\] VGND sg13g2_inv_1
X_0777_ _0430_ VPWR _0185_ VGND net81 _0017_ sg13g2_o21ai_1
XFILLER_29_527 VPWR VGND sg13g2_decap_8
XFILLER_12_438 VPWR VGND sg13g2_decap_8
XFILLER_24_254 VPWR VGND sg13g2_decap_8
XFILLER_20_482 VPWR VGND sg13g2_fill_1
XFILLER_33_79 VPWR VGND sg13g2_decap_8
XFILLER_4_648 VPWR VGND sg13g2_decap_8
XFILLER_0_810 VPWR VGND sg13g2_decap_8
XFILLER_0_821 VPWR VGND sg13g2_fill_2
XFILLER_3_158 VPWR VGND sg13g2_decap_8
XFILLER_15_210 VPWR VGND sg13g2_decap_8
XFILLER_28_593 VPWR VGND sg13g2_decap_8
XFILLER_47_357 VPWR VGND sg13g2_decap_8
XFILLER_15_287 VPWR VGND sg13g2_decap_8
XFILLER_23_90 VPWR VGND sg13g2_decap_8
XFILLER_30_235 VPWR VGND sg13g2_decap_8
XFILLER_43_574 VPWR VGND sg13g2_decap_8
X_0700_ _0252_ net57 _0435_ _0436_ VPWR VGND sg13g2_a21o_1
XFILLER_7_420 VPWR VGND sg13g2_decap_8
X_0631_ net95 VPWR _0384_ VGND net73 state\[42\] sg13g2_o21ai_1
X_0562_ _0088_ _0331_ _0332_ net43 _0217_ VPWR VGND sg13g2_a22oi_1
XFILLER_7_497 VPWR VGND sg13g2_decap_8
XFILLER_31_4 VPWR VGND sg13g2_decap_8
XFILLER_38_357 VPWR VGND sg13g2_decap_8
X_0493_ VGND VPWR net25 daisychain\[6\] _0281_ net42 sg13g2_a21oi_1
XFILLER_21_213 VPWR VGND sg13g2_decap_8
XFILLER_22_769 VPWR VGND sg13g2_decap_8
XFILLER_34_574 VPWR VGND sg13g2_decap_8
XFILLER_34_585 VPWR VGND sg13g2_fill_1
X_1045_ state\[61\] net12 VPWR VGND sg13g2_buf_1
X_0829_ VPWR _0214_ daisychain\[21\] VGND sg13g2_inv_1
XFILLER_9_81 VPWR VGND sg13g2_decap_8
XFILLER_28_68 VPWR VGND sg13g2_decap_8
XFILLER_29_313 VPWR VGND sg13g2_decap_8
XFILLER_12_235 VPWR VGND sg13g2_decap_8
XFILLER_25_585 VPWR VGND sg13g2_decap_8
XFILLER_40_511 VPWR VGND sg13g2_decap_8
XFILLER_40_588 VPWR VGND sg13g2_decap_8
XFILLER_44_56 VPWR VGND sg13g2_decap_8
XFILLER_8_217 VPWR VGND sg13g2_decap_8
XFILLER_5_39 VPWR VGND sg13g2_decap_8
XFILLER_4_445 VPWR VGND sg13g2_decap_8
XFILLER_0_651 VPWR VGND sg13g2_decap_8
XFILLER_47_154 VPWR VGND sg13g2_decap_8
XFILLER_48_644 VPWR VGND sg13g2_decap_8
XFILLER_16_574 VPWR VGND sg13g2_decap_8
XFILLER_28_390 VPWR VGND sg13g2_decap_8
XFILLER_31_522 VPWR VGND sg13g2_decap_8
XFILLER_35_349 VPWR VGND sg13g2_decap_8
XFILLER_43_371 VPWR VGND sg13g2_decap_8
X_0614_ _0101_ _0370_ _0371_ net47 _0230_ VPWR VGND sg13g2_a22oi_1
X_0545_ VGND VPWR net29 daisychain\[19\] _0320_ net50 sg13g2_a21oi_1
X_0476_ _0196_ net59 _0267_ _0268_ VPWR VGND sg13g2_a21o_1
XFILLER_7_294 VPWR VGND sg13g2_decap_8
XFILLER_38_154 VPWR VGND sg13g2_decap_8
XFILLER_39_688 VPWR VGND sg13g2_decap_8
XFILLER_14_48 VPWR VGND sg13g2_decap_8
XFILLER_22_566 VPWR VGND sg13g2_decap_8
XFILLER_34_371 VPWR VGND sg13g2_decap_8
XFILLER_41_308 VPWR VGND sg13g2_decap_8
X_1028_ net102 VGND VPWR _0188_ state\[60\] clknet_5_9__leaf_clk sg13g2_dfrbpq_1
XFILLER_30_14 VPWR VGND sg13g2_fill_1
XFILLER_1_448 VPWR VGND sg13g2_decap_8
XFILLER_29_110 VPWR VGND sg13g2_decap_8
XFILLER_39_56 VPWR VGND sg13g2_decap_8
XFILLER_25_382 VPWR VGND sg13g2_decap_8
XFILLER_29_187 VPWR VGND sg13g2_decap_8
XFILLER_32_319 VPWR VGND sg13g2_decap_8
XFILLER_44_168 VPWR VGND sg13g2_decap_8
XFILLER_45_658 VPWR VGND sg13g2_decap_8
XFILLER_40_385 VPWR VGND sg13g2_decap_8
XFILLER_9_515 VPWR VGND sg13g2_decap_8
XFILLER_4_242 VPWR VGND sg13g2_decap_8
XFILLER_35_146 VPWR VGND sg13g2_decap_8
XFILLER_36_647 VPWR VGND sg13g2_fill_1
XFILLER_48_441 VPWR VGND sg13g2_decap_8
XFILLER_16_371 VPWR VGND sg13g2_decap_8
XFILLER_31_396 VPWR VGND sg13g2_decap_8
XFILLER_8_592 VPWR VGND sg13g2_fill_2
XFILLER_8_581 VPWR VGND sg13g2_decap_8
XFILLER_6_60 VPWR VGND sg13g2_decap_8
XFILLER_39_441 VPWR VGND sg13g2_decap_8
X_0528_ _0209_ net67 _0306_ _0307_ VPWR VGND sg13g2_a21o_1
X_0459_ VPWR _0255_ daisychain\[62\] VGND sg13g2_inv_1
XFILLER_26_168 VPWR VGND sg13g2_decap_8
XFILLER_27_636 VPWR VGND sg13g2_decap_8
XFILLER_41_105 VPWR VGND sg13g2_decap_8
XFILLER_10_536 VPWR VGND sg13g2_decap_8
XFILLER_22_363 VPWR VGND sg13g2_decap_8
XFILLER_41_35 VPWR VGND sg13g2_decap_8
XFILLER_6_529 VPWR VGND sg13g2_decap_8
XFILLER_1_245 VPWR VGND sg13g2_decap_8
XFILLER_9_4 VPWR VGND sg13g2_decap_8
XFILLER_2_18 VPWR VGND sg13g2_decap_8
XFILLER_45_455 VPWR VGND sg13g2_decap_8
XFILLER_49_249 VPWR VGND sg13g2_decap_8
XFILLER_13_363 VPWR VGND sg13g2_decap_8
XFILLER_15_91 VPWR VGND sg13g2_decap_8
XFILLER_17_157 VPWR VGND sg13g2_decap_8
XFILLER_32_116 VPWR VGND sg13g2_decap_8
XFILLER_41_683 VPWR VGND sg13g2_decap_8
XFILLER_9_312 VPWR VGND sg13g2_decap_8
XFILLER_40_182 VPWR VGND sg13g2_decap_8
XFILLER_9_389 VPWR VGND sg13g2_decap_8
XFILLER_36_444 VPWR VGND sg13g2_decap_8
XFILLER_31_193 VPWR VGND sg13g2_decap_8
Xdigitalen.g\[3\].u.inv2 VPWR digitalen.g\[3\].u.OUTP digitalen.g\[3\].u.OUTN VGND
+ sg13g2_inv_1
XFILLER_27_433 VPWR VGND sg13g2_decap_8
XFILLER_36_13 VPWR VGND sg13g2_decap_8
XFILLER_22_160 VPWR VGND sg13g2_decap_8
XFILLER_23_650 VPWR VGND sg13g2_decap_8
XFILLER_23_661 VPWR VGND sg13g2_decap_8
XFILLER_23_694 VPWR VGND sg13g2_decap_8
XFILLER_36_57 VPWR VGND sg13g2_decap_8
XFILLER_42_469 VPWR VGND sg13g2_decap_8
XFILLER_10_333 VPWR VGND sg13g2_decap_8
XFILLER_6_326 VPWR VGND sg13g2_decap_8
XFILLER_2_543 VPWR VGND sg13g2_decap_8
XFILLER_18_444 VPWR VGND sg13g2_decap_8
XFILLER_33_436 VPWR VGND sg13g2_decap_8
XFILLER_37_208 VPWR VGND sg13g2_decap_8
XFILLER_45_252 VPWR VGND sg13g2_decap_8
XFILLER_13_160 VPWR VGND sg13g2_decap_8
X_0862_ VPWR _0028_ state\[38\] VGND sg13g2_inv_1
X_0931_ net101 VGND VPWR _0091_ daisychain\[27\] clknet_5_24__leaf_clk sg13g2_dfrbpq_1
X_0793_ VPWR _0196_ daisychain\[3\] VGND sg13g2_inv_1
XFILLER_9_186 VPWR VGND sg13g2_decap_8
XFILLER_28_208 VPWR VGND sg13g2_decap_8
XFILLER_24_458 VPWR VGND sg13g2_decap_8
XFILLER_36_274 VPWR VGND sg13g2_decap_8
XFILLER_22_48 VPWR VGND sg13g2_decap_8
XFILLER_32_480 VPWR VGND sg13g2_decap_8
Xfanout110 net111 net110 VPWR VGND sg13g2_buf_1
Xfanout121 net122 net121 VPWR VGND sg13g2_buf_1
XFILLER_27_230 VPWR VGND sg13g2_decap_8
XFILLER_47_539 VPWR VGND sg13g2_decap_8
XFILLER_47_56 VPWR VGND sg13g2_decap_8
XFILLER_10_130 VPWR VGND sg13g2_decap_8
XFILLER_11_631 VPWR VGND sg13g2_fill_2
XFILLER_15_469 VPWR VGND sg13g2_decap_8
XFILLER_30_417 VPWR VGND sg13g2_decap_8
XFILLER_42_266 VPWR VGND sg13g2_decap_8
XFILLER_8_28 VPWR VGND sg13g2_decap_8
XFILLER_7_602 VPWR VGND sg13g2_decap_8
XFILLER_12_81 VPWR VGND sg13g2_decap_8
XFILLER_2_340 VPWR VGND sg13g2_decap_8
XFILLER_6_123 VPWR VGND sg13g2_decap_8
XFILLER_18_241 VPWR VGND sg13g2_decap_8
XFILLER_33_233 VPWR VGND sg13g2_decap_8
X_0914_ net107 VGND VPWR _0074_ daisychain\[10\] clknet_5_19__leaf_clk sg13g2_dfrbpq_1
X_0845_ VPWR _0222_ daisychain\[29\] VGND sg13g2_inv_1
X_0776_ _0427_ VPWR _0184_ VGND net92 _0016_ sg13g2_o21ai_1
XFILLER_17_59 VPWR VGND sg13g2_decap_8
XFILLER_12_417 VPWR VGND sg13g2_decap_8
XFILLER_24_233 VPWR VGND sg13g2_decap_8
XFILLER_33_25 VPWR VGND sg13g2_fill_2
XFILLER_33_58 VPWR VGND sg13g2_decap_8
XFILLER_40_726 VPWR VGND sg13g2_decap_8
XFILLER_20_461 VPWR VGND sg13g2_decap_8
XFILLER_3_137 VPWR VGND sg13g2_decap_8
XFILLER_4_627 VPWR VGND sg13g2_decap_8
XFILLER_47_336 VPWR VGND sg13g2_decap_8
XFILLER_15_266 VPWR VGND sg13g2_decap_8
XFILLER_28_572 VPWR VGND sg13g2_decap_8
XFILLER_43_553 VPWR VGND sg13g2_decap_8
XFILLER_11_494 VPWR VGND sg13g2_decap_8
XFILLER_30_214 VPWR VGND sg13g2_decap_8
XFILLER_7_476 VPWR VGND sg13g2_decap_8
X_0630_ _0105_ _0382_ _0383_ net50 _0234_ VPWR VGND sg13g2_a22oi_1
X_0561_ VGND VPWR net27 daisychain\[23\] _0332_ net43 sg13g2_a21oi_1
X_0492_ _0200_ net65 _0279_ _0280_ VPWR VGND sg13g2_a21o_1
XFILLER_24_4 VPWR VGND sg13g2_decap_8
XFILLER_38_336 VPWR VGND sg13g2_decap_8
X_1044_ state\[60\] net11 VPWR VGND sg13g2_buf_1
XFILLER_0_84 VPWR VGND sg13g2_decap_8
XFILLER_21_269 VPWR VGND sg13g2_decap_8
XFILLER_34_553 VPWR VGND sg13g2_decap_8
XFILLER_9_60 VPWR VGND sg13g2_decap_8
XFILLER_30_770 VPWR VGND sg13g2_fill_1
X_0828_ VPWR _0045_ state\[21\] VGND sg13g2_inv_1
X_0759_ _0376_ VPWR _0167_ VGND net97 _0029_ sg13g2_o21ai_1
XFILLER_28_47 VPWR VGND sg13g2_decap_8
XFILLER_25_564 VPWR VGND sg13g2_decap_8
XFILLER_29_369 VPWR VGND sg13g2_decap_8
XFILLER_44_35 VPWR VGND sg13g2_decap_8
XFILLER_45_818 VPWR VGND sg13g2_decap_4
XFILLER_12_214 VPWR VGND sg13g2_decap_8
XFILLER_40_567 VPWR VGND sg13g2_decap_8
Xclkbuf_5_16__f_clk clknet_5_16__leaf_clk clknet_4_8_0_clk VPWR VGND sg13g2_buf_16
XFILLER_0_630 VPWR VGND sg13g2_decap_8
XFILLER_5_18 VPWR VGND sg13g2_decap_8
XFILLER_4_424 VPWR VGND sg13g2_decap_8
XFILLER_18_80 VPWR VGND sg13g2_decap_8
XFILLER_35_328 VPWR VGND sg13g2_decap_8
XFILLER_47_133 VPWR VGND sg13g2_decap_8
XFILLER_48_623 VPWR VGND sg13g2_decap_8
XFILLER_16_553 VPWR VGND sg13g2_decap_8
XFILLER_31_501 VPWR VGND sg13g2_decap_8
XFILLER_31_578 VPWR VGND sg13g2_decap_8
XFILLER_43_350 VPWR VGND sg13g2_decap_8
XFILLER_11_291 VPWR VGND sg13g2_decap_8
X_0613_ VGND VPWR net28 daisychain\[36\] _0371_ net47 sg13g2_a21oi_1
XFILLER_7_273 VPWR VGND sg13g2_decap_8
X_0544_ _0213_ net66 _0318_ _0319_ VPWR VGND sg13g2_a21o_1
X_0475_ net82 VPWR _0267_ VGND net59 state\[3\] sg13g2_o21ai_1
XFILLER_27_818 VPWR VGND sg13g2_decap_4
XFILLER_34_350 VPWR VGND sg13g2_decap_8
XFILLER_38_133 VPWR VGND sg13g2_decap_8
X_1027_ net102 VGND VPWR _0187_ state\[59\] clknet_5_0__leaf_clk sg13g2_dfrbpq_1
XFILLER_14_27 VPWR VGND sg13g2_decap_8
XFILLER_22_545 VPWR VGND sg13g2_decap_8
XFILLER_1_427 VPWR VGND sg13g2_decap_8
XFILLER_29_166 VPWR VGND sg13g2_decap_8
XFILLER_39_35 VPWR VGND sg13g2_decap_8
XFILLER_45_637 VPWR VGND sg13g2_decap_8
XFILLER_13_545 VPWR VGND sg13g2_decap_8
XFILLER_17_339 VPWR VGND sg13g2_decap_8
XFILLER_25_361 VPWR VGND sg13g2_decap_8
XFILLER_44_147 VPWR VGND sg13g2_decap_8
XFILLER_40_364 VPWR VGND sg13g2_decap_8
XFILLER_4_221 VPWR VGND sg13g2_decap_8
XFILLER_48_420 VPWR VGND sg13g2_decap_8
XFILLER_4_298 VPWR VGND sg13g2_decap_8
XFILLER_16_350 VPWR VGND sg13g2_decap_8
XFILLER_35_125 VPWR VGND sg13g2_decap_8
XFILLER_36_637 VPWR VGND sg13g2_decap_4
XFILLER_36_659 VPWR VGND sg13g2_fill_2
XFILLER_48_497 VPWR VGND sg13g2_decap_8
XFILLER_31_375 VPWR VGND sg13g2_decap_8
XFILLER_44_681 VPWR VGND sg13g2_decap_4
XFILLER_8_560 VPWR VGND sg13g2_decap_8
XFILLER_27_615 VPWR VGND sg13g2_decap_8
XFILLER_39_420 VPWR VGND sg13g2_decap_8
X_0527_ net90 VPWR _0306_ VGND net67 state\[16\] sg13g2_o21ai_1
X_0458_ VPWR _0023_ state\[62\] VGND sg13g2_inv_1
XFILLER_22_342 VPWR VGND sg13g2_decap_8
XFILLER_26_147 VPWR VGND sg13g2_decap_8
XFILLER_10_515 VPWR VGND sg13g2_decap_8
XFILLER_41_14 VPWR VGND sg13g2_decap_8
XFILLER_6_508 VPWR VGND sg13g2_decap_8
XFILLER_1_224 VPWR VGND sg13g2_decap_8
XFILLER_49_228 VPWR VGND sg13g2_decap_8
XFILLER_17_136 VPWR VGND sg13g2_decap_8
XFILLER_45_434 VPWR VGND sg13g2_decap_8
XFILLER_13_342 VPWR VGND sg13g2_decap_8
XFILLER_15_70 VPWR VGND sg13g2_decap_8
XFILLER_26_692 VPWR VGND sg13g2_decap_4
XFILLER_40_161 VPWR VGND sg13g2_decap_8
XFILLER_41_640 VPWR VGND sg13g2_fill_2
XFILLER_41_695 VPWR VGND sg13g2_fill_2
XFILLER_9_368 VPWR VGND sg13g2_decap_8
XFILLER_5_585 VPWR VGND sg13g2_decap_8
XFILLER_49_795 VPWR VGND sg13g2_decap_8
XFILLER_17_692 VPWR VGND sg13g2_fill_1
XFILLER_23_139 VPWR VGND sg13g2_decap_8
XFILLER_24_629 VPWR VGND sg13g2_decap_8
XFILLER_36_423 VPWR VGND sg13g2_decap_8
XFILLER_48_294 VPWR VGND sg13g2_decap_8
XFILLER_11_39 VPWR VGND sg13g2_decap_8
XFILLER_31_172 VPWR VGND sg13g2_decap_8
XFILLER_27_412 VPWR VGND sg13g2_decap_8
XFILLER_39_294 VPWR VGND sg13g2_decap_8
XFILLER_10_312 VPWR VGND sg13g2_decap_8
XFILLER_14_139 VPWR VGND sg13g2_decap_8
XFILLER_15_629 VPWR VGND sg13g2_fill_2
XFILLER_27_489 VPWR VGND sg13g2_decap_8
XFILLER_42_448 VPWR VGND sg13g2_decap_8
XFILLER_10_389 VPWR VGND sg13g2_decap_8
XFILLER_2_522 VPWR VGND sg13g2_decap_8
XFILLER_6_305 VPWR VGND sg13g2_decap_8
XFILLER_2_599 VPWR VGND sg13g2_decap_8
XFILLER_18_423 VPWR VGND sg13g2_decap_8
XFILLER_26_91 VPWR VGND sg13g2_decap_8
XFILLER_33_415 VPWR VGND sg13g2_decap_8
XFILLER_45_231 VPWR VGND sg13g2_decap_8
XFILLER_14_695 VPWR VGND sg13g2_fill_1
X_0861_ VPWR _0230_ daisychain\[37\] VGND sg13g2_inv_1
X_0930_ net106 VGND VPWR _0090_ daisychain\[26\] clknet_5_25__leaf_clk sg13g2_dfrbpq_1
X_0792_ VPWR _0057_ state\[3\] VGND sg13g2_inv_1
XFILLER_9_165 VPWR VGND sg13g2_decap_8
XFILLER_5_382 VPWR VGND sg13g2_decap_8
XFILLER_36_253 VPWR VGND sg13g2_decap_8
XFILLER_37_743 VPWR VGND sg13g2_fill_1
XFILLER_3_95 VPWR VGND sg13g2_decap_8
XFILLER_49_592 VPWR VGND sg13g2_decap_8
XFILLER_11_109 VPWR VGND sg13g2_decap_8
XFILLER_24_437 VPWR VGND sg13g2_decap_8
XFILLER_3_319 VPWR VGND sg13g2_decap_8
XFILLER_47_35 VPWR VGND sg13g2_decap_8
XFILLER_47_518 VPWR VGND sg13g2_decap_8
Xfanout100 net4 net100 VPWR VGND sg13g2_buf_1
Xfanout111 net112 net111 VPWR VGND sg13g2_buf_1
Xfanout122 net1 net122 VPWR VGND sg13g2_buf_1
XFILLER_15_448 VPWR VGND sg13g2_decap_8
XFILLER_27_286 VPWR VGND sg13g2_decap_8
XFILLER_42_245 VPWR VGND sg13g2_decap_8
XFILLER_10_186 VPWR VGND sg13g2_decap_8
XFILLER_6_102 VPWR VGND sg13g2_decap_8
XFILLER_12_60 VPWR VGND sg13g2_decap_8
XFILLER_7_669 VPWR VGND sg13g2_decap_4
XFILLER_6_179 VPWR VGND sg13g2_decap_8
XFILLER_18_220 VPWR VGND sg13g2_decap_8
XFILLER_19_743 VPWR VGND sg13g2_fill_1
XFILLER_26_8 VPWR VGND sg13g2_fill_2
XFILLER_2_396 VPWR VGND sg13g2_decap_8
XFILLER_18_297 VPWR VGND sg13g2_decap_8
XFILLER_33_212 VPWR VGND sg13g2_decap_8
XFILLER_33_289 VPWR VGND sg13g2_decap_8
XFILLER_46_595 VPWR VGND sg13g2_decap_8
X_0913_ net104 VGND VPWR _0073_ daisychain\[9\] clknet_5_19__leaf_clk sg13g2_dfrbpq_1
X_0844_ VPWR _0053_ state\[29\] VGND sg13g2_inv_1
X_0775_ _0424_ VPWR _0183_ VGND net92 _0015_ sg13g2_o21ai_1
XFILLER_45_0 VPWR VGND sg13g2_decap_8
XFILLER_24_212 VPWR VGND sg13g2_decap_8
XFILLER_37_573 VPWR VGND sg13g2_decap_8
XFILLER_20_440 VPWR VGND sg13g2_decap_8
XFILLER_24_289 VPWR VGND sg13g2_decap_8
XFILLER_33_37 VPWR VGND sg13g2_decap_8
XFILLER_3_116 VPWR VGND sg13g2_decap_8
XFILLER_4_606 VPWR VGND sg13g2_decap_8
XFILLER_28_551 VPWR VGND sg13g2_decap_8
XFILLER_47_315 VPWR VGND sg13g2_decap_8
XFILLER_48_805 VPWR VGND sg13g2_decap_8
XFILLER_15_245 VPWR VGND sg13g2_decap_8
XFILLER_43_532 VPWR VGND sg13g2_decap_8
XFILLER_11_473 VPWR VGND sg13g2_decap_8
XFILLER_7_455 VPWR VGND sg13g2_decap_8
XFILLER_2_193 VPWR VGND sg13g2_decap_8
X_0560_ _0217_ net66 _0330_ _0331_ VPWR VGND sg13g2_a21o_1
X_0491_ net87 VPWR _0279_ VGND net64 state\[7\] sg13g2_o21ai_1
XFILLER_0_63 VPWR VGND sg13g2_decap_8
XFILLER_19_551 VPWR VGND sg13g2_decap_8
XFILLER_34_532 VPWR VGND sg13g2_decap_8
XFILLER_38_315 VPWR VGND sg13g2_decap_8
XFILLER_46_392 VPWR VGND sg13g2_decap_8
X_1043_ state\[59\] net10 VPWR VGND sg13g2_buf_1
XFILLER_21_248 VPWR VGND sg13g2_decap_8
XFILLER_30_782 VPWR VGND sg13g2_decap_8
XFILLER_1_609 VPWR VGND sg13g2_decap_8
X_0827_ VPWR _0213_ daisychain\[20\] VGND sg13g2_inv_1
X_0758_ _0373_ VPWR _0166_ VGND net93 _0028_ sg13g2_o21ai_1
XFILLER_0_119 VPWR VGND sg13g2_decap_8
XFILLER_29_348 VPWR VGND sg13g2_decap_8
X_0689_ VGND VPWR net31 daisychain\[55\] _0428_ net47 sg13g2_a21oi_1
XFILLER_25_543 VPWR VGND sg13g2_decap_8
XFILLER_44_14 VPWR VGND sg13g2_decap_8
XFILLER_44_329 VPWR VGND sg13g2_decap_8
XFILLER_40_546 VPWR VGND sg13g2_decap_8
XFILLER_4_403 VPWR VGND sg13g2_decap_8
XFILLER_48_602 VPWR VGND sg13g2_decap_8
XFILLER_0_686 VPWR VGND sg13g2_decap_8
XFILLER_16_532 VPWR VGND sg13g2_decap_8
XFILLER_35_307 VPWR VGND sg13g2_decap_8
XFILLER_47_112 VPWR VGND sg13g2_decap_8
XFILLER_47_189 VPWR VGND sg13g2_decap_8
XFILLER_48_679 VPWR VGND sg13g2_decap_8
XFILLER_31_557 VPWR VGND sg13g2_decap_8
XFILLER_34_91 VPWR VGND sg13g2_decap_8
XFILLER_11_270 VPWR VGND sg13g2_decap_8
X_0612_ _0230_ net70 _0369_ _0370_ VPWR VGND sg13g2_a21o_1
XFILLER_7_252 VPWR VGND sg13g2_decap_8
XFILLER_38_112 VPWR VGND sg13g2_decap_8
XFILLER_39_668 VPWR VGND sg13g2_decap_4
XFILLER_3_480 VPWR VGND sg13g2_decap_8
X_0543_ net89 VPWR _0318_ VGND net66 state\[20\] sg13g2_o21ai_1
X_0474_ _0066_ _0265_ _0266_ net36 _0195_ VPWR VGND sg13g2_a22oi_1
XFILLER_22_524 VPWR VGND sg13g2_decap_8
XFILLER_26_329 VPWR VGND sg13g2_decap_8
XFILLER_38_189 VPWR VGND sg13g2_decap_8
XFILLER_39_679 VPWR VGND sg13g2_decap_4
X_1026_ net102 VGND VPWR _0186_ state\[58\] clknet_5_8__leaf_clk sg13g2_dfrbpq_1
Xclkbuf_5_22__f_clk clknet_5_22__leaf_clk clknet_4_11_0_clk VPWR VGND sg13g2_buf_16
XFILLER_1_406 VPWR VGND sg13g2_decap_8
XFILLER_39_14 VPWR VGND sg13g2_decap_8
XFILLER_17_318 VPWR VGND sg13g2_decap_8
XFILLER_29_145 VPWR VGND sg13g2_decap_8
XFILLER_44_126 VPWR VGND sg13g2_decap_8
XFILLER_45_616 VPWR VGND sg13g2_decap_8
XFILLER_13_524 VPWR VGND sg13g2_decap_8
XFILLER_25_340 VPWR VGND sg13g2_decap_8
XFILLER_40_343 VPWR VGND sg13g2_decap_8
XFILLER_21_590 VPWR VGND sg13g2_decap_8
XFILLER_4_200 VPWR VGND sg13g2_decap_8
XFILLER_0_483 VPWR VGND sg13g2_decap_8
XFILLER_4_277 VPWR VGND sg13g2_decap_8
XFILLER_35_104 VPWR VGND sg13g2_decap_8
XFILLER_36_605 VPWR VGND sg13g2_fill_1
XFILLER_48_476 VPWR VGND sg13g2_decap_8
XFILLER_31_354 VPWR VGND sg13g2_decap_8
X_0526_ _0079_ _0304_ _0305_ net41 _0208_ VPWR VGND sg13g2_a22oi_1
XFILLER_6_95 VPWR VGND sg13g2_decap_8
XFILLER_26_126 VPWR VGND sg13g2_decap_8
XFILLER_39_476 VPWR VGND sg13g2_fill_2
X_0457_ VPWR _0254_ daisychain\[61\] VGND sg13g2_inv_1
XFILLER_22_321 VPWR VGND sg13g2_decap_8
XFILLER_23_800 VPWR VGND sg13g2_fill_1
XFILLER_23_811 VPWR VGND sg13g2_decap_8
XFILLER_23_822 VPWR VGND sg13g2_fill_1
X_1009_ net117 VGND VPWR _0169_ state\[41\] clknet_5_6__leaf_clk sg13g2_dfrbpq_1
XFILLER_22_398 VPWR VGND sg13g2_decap_8
XFILLER_1_203 VPWR VGND sg13g2_decap_8
XFILLER_49_207 VPWR VGND sg13g2_decap_8
XFILLER_17_115 VPWR VGND sg13g2_decap_8
XFILLER_18_627 VPWR VGND sg13g2_fill_2
XFILLER_33_619 VPWR VGND sg13g2_fill_2
XFILLER_45_413 VPWR VGND sg13g2_decap_8
XFILLER_13_321 VPWR VGND sg13g2_decap_8
XFILLER_13_398 VPWR VGND sg13g2_decap_8
XFILLER_40_140 VPWR VGND sg13g2_decap_8
XFILLER_9_347 VPWR VGND sg13g2_decap_8
XFILLER_31_81 VPWR VGND sg13g2_decap_8
XFILLER_5_564 VPWR VGND sg13g2_decap_8
XFILLER_0_280 VPWR VGND sg13g2_decap_8
XFILLER_36_402 VPWR VGND sg13g2_decap_8
XFILLER_48_273 VPWR VGND sg13g2_decap_8
XFILLER_49_774 VPWR VGND sg13g2_decap_8
XFILLER_23_118 VPWR VGND sg13g2_decap_8
XFILLER_24_608 VPWR VGND sg13g2_decap_8
XFILLER_31_151 VPWR VGND sg13g2_decap_8
XFILLER_32_630 VPWR VGND sg13g2_decap_4
XFILLER_36_479 VPWR VGND sg13g2_decap_8
XFILLER_44_490 VPWR VGND sg13g2_decap_8
XFILLER_11_18 VPWR VGND sg13g2_decap_8
X_0509_ VGND VPWR net25 daisychain\[10\] _0293_ net40 sg13g2_a21oi_1
XFILLER_14_118 VPWR VGND sg13g2_decap_8
XFILLER_27_468 VPWR VGND sg13g2_decap_8
XFILLER_39_273 VPWR VGND sg13g2_decap_8
XFILLER_42_427 VPWR VGND sg13g2_decap_8
XFILLER_10_368 VPWR VGND sg13g2_decap_8
XFILLER_22_195 VPWR VGND sg13g2_decap_8
XFILLER_7_818 VPWR VGND sg13g2_decap_4
XFILLER_7_807 VPWR VGND sg13g2_fill_1
XFILLER_2_501 VPWR VGND sg13g2_decap_8
XFILLER_18_402 VPWR VGND sg13g2_decap_8
XFILLER_2_578 VPWR VGND sg13g2_decap_8
XFILLER_45_210 VPWR VGND sg13g2_decap_8
XFILLER_46_700 VPWR VGND sg13g2_decap_8
XFILLER_18_479 VPWR VGND sg13g2_decap_8
XFILLER_26_490 VPWR VGND sg13g2_decap_8
XFILLER_26_70 VPWR VGND sg13g2_decap_8
XFILLER_45_287 VPWR VGND sg13g2_decap_8
XFILLER_13_195 VPWR VGND sg13g2_decap_8
XFILLER_42_91 VPWR VGND sg13g2_decap_8
X_0860_ VPWR _0027_ state\[37\] VGND sg13g2_inv_1
X_0791_ VPWR _0195_ daisychain\[2\] VGND sg13g2_inv_1
XFILLER_9_144 VPWR VGND sg13g2_decap_8
XFILLER_3_74 VPWR VGND sg13g2_decap_8
XFILLER_5_361 VPWR VGND sg13g2_decap_8
XFILLER_36_232 VPWR VGND sg13g2_decap_8
XFILLER_49_571 VPWR VGND sg13g2_decap_8
X_0989_ net109 VGND VPWR _0149_ state\[21\] clknet_5_30__leaf_clk sg13g2_dfrbpq_1
XFILLER_47_14 VPWR VGND sg13g2_decap_8
Xfanout101 net122 net101 VPWR VGND sg13g2_buf_1
Xfanout112 net122 net112 VPWR VGND sg13g2_buf_1
Xfanout123 net1 net123 VPWR VGND sg13g2_buf_1
XFILLER_15_427 VPWR VGND sg13g2_decap_8
XFILLER_27_265 VPWR VGND sg13g2_decap_8
XFILLER_28_788 VPWR VGND sg13g2_fill_2
XFILLER_28_799 VPWR VGND sg13g2_fill_1
XFILLER_42_224 VPWR VGND sg13g2_decap_8
XFILLER_10_165 VPWR VGND sg13g2_decap_8
XFILLER_11_633 VPWR VGND sg13g2_fill_1
XFILLER_23_482 VPWR VGND sg13g2_decap_8
XFILLER_6_158 VPWR VGND sg13g2_decap_8
XFILLER_2_375 VPWR VGND sg13g2_decap_8
XFILLER_3_810 VPWR VGND sg13g2_decap_8
XFILLER_3_821 VPWR VGND sg13g2_fill_2
XFILLER_18_276 VPWR VGND sg13g2_decap_8
XFILLER_19_8 VPWR VGND sg13g2_fill_1
XFILLER_46_574 VPWR VGND sg13g2_decap_8
Xclkbuf_5_3__f_clk clknet_5_3__leaf_clk clknet_4_1_0_clk VPWR VGND sg13g2_buf_16
XFILLER_14_482 VPWR VGND sg13g2_decap_8
XFILLER_33_268 VPWR VGND sg13g2_decap_8
X_0912_ net104 VGND VPWR _0072_ daisychain\[8\] clknet_5_20__leaf_clk sg13g2_dfrbpq_1
X_0843_ VPWR _0221_ daisychain\[28\] VGND sg13g2_inv_1
X_0774_ _0421_ VPWR _0182_ VGND net93 _0014_ sg13g2_o21ai_1
XFILLER_38_0 VPWR VGND sg13g2_decap_8
XFILLER_24_268 VPWR VGND sg13g2_decap_8
XFILLER_37_552 VPWR VGND sg13g2_decap_8
XFILLER_28_530 VPWR VGND sg13g2_decap_8
XFILLER_43_511 VPWR VGND sg13g2_decap_8
XFILLER_15_224 VPWR VGND sg13g2_decap_8
XFILLER_30_249 VPWR VGND sg13g2_decap_8
XFILLER_43_588 VPWR VGND sg13g2_decap_8
XFILLER_11_452 VPWR VGND sg13g2_decap_8
XFILLER_7_434 VPWR VGND sg13g2_decap_8
XFILLER_2_172 VPWR VGND sg13g2_decap_8
XFILLER_3_662 VPWR VGND sg13g2_decap_8
XFILLER_3_673 VPWR VGND sg13g2_fill_2
X_0490_ _0070_ _0277_ _0278_ net40 _0199_ VPWR VGND sg13g2_a22oi_1
XFILLER_0_42 VPWR VGND sg13g2_decap_8
XFILLER_19_585 VPWR VGND sg13g2_decap_8
XFILLER_34_511 VPWR VGND sg13g2_decap_8
XFILLER_46_371 VPWR VGND sg13g2_decap_8
X_1042_ state\[58\] net9 VPWR VGND sg13g2_buf_1
XFILLER_21_227 VPWR VGND sg13g2_decap_8
XFILLER_30_761 VPWR VGND sg13g2_decap_8
XFILLER_9_95 VPWR VGND sg13g2_decap_8
X_0826_ VPWR _0044_ state\[20\] VGND sg13g2_inv_1
X_0757_ _0370_ VPWR _0165_ VGND net92 _0027_ sg13g2_o21ai_1
X_0688_ _0249_ net70 _0426_ _0427_ VPWR VGND sg13g2_a21o_1
XFILLER_29_327 VPWR VGND sg13g2_decap_8
XFILLER_44_308 VPWR VGND sg13g2_decap_8
Xclkbuf_4_15_0_clk clknet_0_clk clknet_4_15_0_clk VPWR VGND sg13g2_buf_8
XFILLER_12_249 VPWR VGND sg13g2_decap_8
XFILLER_25_522 VPWR VGND sg13g2_decap_8
XFILLER_25_599 VPWR VGND sg13g2_decap_8
XFILLER_40_525 VPWR VGND sg13g2_decap_8
XFILLER_20_293 VPWR VGND sg13g2_decap_8
XFILLER_0_665 VPWR VGND sg13g2_decap_8
XFILLER_4_459 VPWR VGND sg13g2_decap_8
XFILLER_16_511 VPWR VGND sg13g2_decap_8
XFILLER_47_168 VPWR VGND sg13g2_decap_8
XFILLER_48_658 VPWR VGND sg13g2_decap_8
XFILLER_16_588 VPWR VGND sg13g2_decap_8
XFILLER_31_536 VPWR VGND sg13g2_decap_8
XFILLER_34_70 VPWR VGND sg13g2_decap_8
XFILLER_43_385 VPWR VGND sg13g2_decap_8
XFILLER_7_231 VPWR VGND sg13g2_decap_8
X_0611_ net92 VPWR _0369_ VGND net70 state\[37\] sg13g2_o21ai_1
X_0542_ _0083_ _0316_ _0317_ net51 _0212_ VPWR VGND sg13g2_a22oi_1
XFILLER_26_308 VPWR VGND sg13g2_decap_8
XFILLER_38_168 VPWR VGND sg13g2_decap_8
X_0473_ VGND VPWR net23 daisychain\[1\] _0266_ net36 sg13g2_a21oi_1
XFILLER_19_393 VPWR VGND sg13g2_decap_8
XFILLER_22_503 VPWR VGND sg13g2_decap_8
XFILLER_34_385 VPWR VGND sg13g2_decap_8
X_1025_ net102 VGND VPWR _0185_ state\[57\] clknet_5_8__leaf_clk sg13g2_dfrbpq_1
XFILLER_30_39 VPWR VGND sg13g2_decap_8
X_0809_ VPWR _0204_ daisychain\[11\] VGND sg13g2_inv_1
XFILLER_29_124 VPWR VGND sg13g2_decap_8
XFILLER_44_105 VPWR VGND sg13g2_decap_8
XFILLER_13_503 VPWR VGND sg13g2_decap_8
XFILLER_13_569 VPWR VGND sg13g2_decap_8
XFILLER_25_396 VPWR VGND sg13g2_decap_8
XFILLER_40_322 VPWR VGND sg13g2_decap_8
XFILLER_40_399 VPWR VGND sg13g2_decap_8
XFILLER_9_529 VPWR VGND sg13g2_decap_8
XFILLER_20_83 VPWR VGND sg13g2_decap_8
XFILLER_5_768 VPWR VGND sg13g2_decap_8
XFILLER_4_256 VPWR VGND sg13g2_decap_8
XFILLER_0_462 VPWR VGND sg13g2_decap_8
XFILLER_48_455 VPWR VGND sg13g2_decap_8
XFILLER_16_385 VPWR VGND sg13g2_decap_8
XFILLER_31_333 VPWR VGND sg13g2_decap_8
XFILLER_43_182 VPWR VGND sg13g2_decap_8
XFILLER_45_91 VPWR VGND sg13g2_decap_8
XANTENNA_1 VPWR VGND digitalen.g\[0\].u.OUTP sg13g2_antennanp
X_0525_ VGND VPWR net26 daisychain\[14\] _0305_ net41 sg13g2_a21oi_1
X_0456_ VPWR _0021_ state\[61\] VGND sg13g2_inv_1
XFILLER_6_74 VPWR VGND sg13g2_decap_8
XFILLER_19_190 VPWR VGND sg13g2_decap_8
XFILLER_26_105 VPWR VGND sg13g2_decap_8
XFILLER_39_455 VPWR VGND sg13g2_decap_8
XFILLER_42_609 VPWR VGND sg13g2_decap_8
XFILLER_22_300 VPWR VGND sg13g2_decap_8
XFILLER_22_377 VPWR VGND sg13g2_decap_8
XFILLER_25_39 VPWR VGND sg13g2_decap_8
XFILLER_34_182 VPWR VGND sg13g2_decap_8
XFILLER_41_119 VPWR VGND sg13g2_decap_8
X_1008_ net117 VGND VPWR _0168_ state\[40\] clknet_5_13__leaf_clk sg13g2_dfrbpq_1
XFILLER_41_49 VPWR VGND sg13g2_decap_8
XFILLER_1_259 VPWR VGND sg13g2_decap_8
XFILLER_13_300 VPWR VGND sg13g2_decap_8
XFILLER_25_193 VPWR VGND sg13g2_decap_8
XFILLER_45_469 VPWR VGND sg13g2_decap_8
XFILLER_13_377 VPWR VGND sg13g2_decap_8
XFILLER_31_60 VPWR VGND sg13g2_decap_8
XFILLER_40_196 VPWR VGND sg13g2_decap_8
XFILLER_41_664 VPWR VGND sg13g2_fill_1
XFILLER_9_326 VPWR VGND sg13g2_decap_8
XFILLER_5_543 VPWR VGND sg13g2_decap_8
XFILLER_36_458 VPWR VGND sg13g2_decap_8
XFILLER_48_252 VPWR VGND sg13g2_decap_8
XFILLER_49_753 VPWR VGND sg13g2_decap_8
XFILLER_16_182 VPWR VGND sg13g2_decap_8
XFILLER_17_683 VPWR VGND sg13g2_decap_8
XFILLER_31_130 VPWR VGND sg13g2_decap_8
XFILLER_32_642 VPWR VGND sg13g2_fill_2
XFILLER_8_392 VPWR VGND sg13g2_decap_8
XFILLER_39_252 VPWR VGND sg13g2_decap_8
X_0508_ _0204_ net64 _0291_ _0292_ VPWR VGND sg13g2_a21o_1
XFILLER_27_447 VPWR VGND sg13g2_decap_8
XFILLER_42_406 VPWR VGND sg13g2_decap_8
XFILLER_10_347 VPWR VGND sg13g2_decap_8
XFILLER_22_174 VPWR VGND sg13g2_decap_8
XFILLER_2_557 VPWR VGND sg13g2_decap_8
XFILLER_18_458 VPWR VGND sg13g2_decap_8
XFILLER_13_174 VPWR VGND sg13g2_decap_8
XFILLER_41_483 VPWR VGND sg13g2_decap_8
XFILLER_45_266 VPWR VGND sg13g2_decap_8
XFILLER_9_123 VPWR VGND sg13g2_decap_8
XFILLER_42_70 VPWR VGND sg13g2_decap_8
X_0790_ VPWR _0054_ state\[2\] VGND sg13g2_inv_1
XFILLER_5_340 VPWR VGND sg13g2_decap_8
XFILLER_3_53 VPWR VGND sg13g2_decap_8
XFILLER_49_550 VPWR VGND sg13g2_decap_8
XFILLER_36_211 VPWR VGND sg13g2_decap_8
XFILLER_36_288 VPWR VGND sg13g2_decap_8
XFILLER_22_18 VPWR VGND sg13g2_fill_1
XFILLER_32_494 VPWR VGND sg13g2_decap_8
X_0988_ net109 VGND VPWR _0148_ state\[20\] clknet_5_30__leaf_clk sg13g2_dfrbpq_1
Xfanout102 net122 net102 VPWR VGND sg13g2_buf_1
Xfanout113 net114 net113 VPWR VGND sg13g2_buf_1
XFILLER_27_244 VPWR VGND sg13g2_decap_8
XFILLER_15_406 VPWR VGND sg13g2_decap_8
XFILLER_23_461 VPWR VGND sg13g2_decap_8
XFILLER_42_203 VPWR VGND sg13g2_decap_8
XFILLER_10_144 VPWR VGND sg13g2_decap_8
XFILLER_12_95 VPWR VGND sg13g2_decap_8
XFILLER_7_616 VPWR VGND sg13g2_fill_2
XFILLER_6_137 VPWR VGND sg13g2_decap_8
XFILLER_2_354 VPWR VGND sg13g2_decap_8
XFILLER_38_509 VPWR VGND sg13g2_decap_8
XFILLER_18_255 VPWR VGND sg13g2_decap_8
XFILLER_46_553 VPWR VGND sg13g2_decap_8
XFILLER_14_461 VPWR VGND sg13g2_decap_8
XFILLER_21_409 VPWR VGND sg13g2_decap_8
XFILLER_33_247 VPWR VGND sg13g2_decap_8
XFILLER_41_280 VPWR VGND sg13g2_decap_8
X_0911_ net107 VGND VPWR _0071_ daisychain\[7\] clknet_5_20__leaf_clk sg13g2_dfrbpq_1
X_0842_ VPWR _0052_ state\[28\] VGND sg13g2_inv_1
X_0773_ _0418_ VPWR _0181_ VGND net93 _0013_ sg13g2_o21ai_1
XFILLER_37_531 VPWR VGND sg13g2_decap_8
XFILLER_24_247 VPWR VGND sg13g2_decap_8
XFILLER_37_597 VPWR VGND sg13g2_fill_2
XFILLER_20_475 VPWR VGND sg13g2_decap_8
XFILLER_32_291 VPWR VGND sg13g2_decap_8
XFILLER_0_803 VPWR VGND sg13g2_decap_8
XFILLER_15_203 VPWR VGND sg13g2_decap_8
XFILLER_28_586 VPWR VGND sg13g2_decap_8
XFILLER_11_431 VPWR VGND sg13g2_decap_8
XFILLER_24_781 VPWR VGND sg13g2_decap_4
XFILLER_30_228 VPWR VGND sg13g2_decap_8
XFILLER_43_567 VPWR VGND sg13g2_decap_8
XFILLER_7_413 VPWR VGND sg13g2_decap_8
XFILLER_23_83 VPWR VGND sg13g2_decap_8
XFILLER_3_641 VPWR VGND sg13g2_decap_8
XFILLER_2_151 VPWR VGND sg13g2_decap_8
XFILLER_48_91 VPWR VGND sg13g2_decap_8
XFILLER_0_21 VPWR VGND sg13g2_decap_8
XFILLER_0_98 VPWR VGND sg13g2_decap_8
XFILLER_21_206 VPWR VGND sg13g2_decap_8
XFILLER_34_567 VPWR VGND sg13g2_decap_8
XFILLER_46_350 VPWR VGND sg13g2_decap_8
X_1041_ state\[57\] net8 VPWR VGND sg13g2_buf_1
X_0825_ VPWR _0212_ daisychain\[19\] VGND sg13g2_inv_1
XFILLER_9_74 VPWR VGND sg13g2_decap_8
X_0756_ _0367_ VPWR _0164_ VGND net94 _0026_ sg13g2_o21ai_1
X_0687_ net92 VPWR _0426_ VGND net70 state\[56\] sg13g2_o21ai_1
XFILLER_25_501 VPWR VGND sg13g2_decap_8
XFILLER_29_306 VPWR VGND sg13g2_decap_8
XFILLER_12_228 VPWR VGND sg13g2_decap_8
XFILLER_25_578 VPWR VGND sg13g2_decap_8
XFILLER_40_504 VPWR VGND sg13g2_decap_8
XFILLER_44_49 VPWR VGND sg13g2_decap_8
XFILLER_20_272 VPWR VGND sg13g2_decap_8
XFILLER_4_438 VPWR VGND sg13g2_decap_8
XFILLER_0_644 VPWR VGND sg13g2_decap_8
XFILLER_48_637 VPWR VGND sg13g2_decap_8
XFILLER_16_567 VPWR VGND sg13g2_decap_8
XFILLER_18_94 VPWR VGND sg13g2_decap_8
XFILLER_28_383 VPWR VGND sg13g2_decap_8
XFILLER_31_515 VPWR VGND sg13g2_decap_8
XFILLER_43_364 VPWR VGND sg13g2_decap_8
XFILLER_47_147 VPWR VGND sg13g2_decap_8
XFILLER_7_210 VPWR VGND sg13g2_decap_8
X_0610_ _0100_ _0367_ _0368_ net47 _0229_ VPWR VGND sg13g2_a22oi_1
X_0541_ VGND VPWR net29 daisychain\[18\] _0317_ net51 sg13g2_a21oi_1
X_0472_ _0195_ net59 _0264_ _0265_ VPWR VGND sg13g2_a21o_1
XFILLER_7_287 VPWR VGND sg13g2_decap_8
XFILLER_19_372 VPWR VGND sg13g2_decap_8
XFILLER_22_4 VPWR VGND sg13g2_decap_8
XFILLER_38_147 VPWR VGND sg13g2_decap_8
X_1024_ net115 VGND VPWR _0184_ state\[56\] clknet_5_10__leaf_clk sg13g2_dfrbpq_1
XFILLER_22_559 VPWR VGND sg13g2_decap_8
XFILLER_34_364 VPWR VGND sg13g2_decap_8
X_0808_ VPWR _0034_ state\[11\] VGND sg13g2_inv_1
XFILLER_29_103 VPWR VGND sg13g2_decap_8
XFILLER_39_49 VPWR VGND sg13g2_decap_8
X_0739_ _0316_ VPWR _0147_ VGND net96 _0042_ sg13g2_o21ai_1
XFILLER_25_375 VPWR VGND sg13g2_decap_8
XFILLER_37_180 VPWR VGND sg13g2_decap_8
XFILLER_40_301 VPWR VGND sg13g2_decap_8
XFILLER_13_559 VPWR VGND sg13g2_decap_4
XFILLER_40_378 VPWR VGND sg13g2_decap_8
XFILLER_9_508 VPWR VGND sg13g2_decap_8
XFILLER_20_62 VPWR VGND sg13g2_decap_8
XFILLER_4_235 VPWR VGND sg13g2_decap_8
XFILLER_0_441 VPWR VGND sg13g2_decap_8
XFILLER_29_82 VPWR VGND sg13g2_decap_8
XFILLER_48_434 VPWR VGND sg13g2_decap_8
XFILLER_16_364 VPWR VGND sg13g2_decap_8
XFILLER_28_180 VPWR VGND sg13g2_decap_8
XFILLER_31_312 VPWR VGND sg13g2_decap_8
XFILLER_35_139 VPWR VGND sg13g2_decap_8
XFILLER_43_161 VPWR VGND sg13g2_decap_8
XFILLER_44_651 VPWR VGND sg13g2_decap_8
XFILLER_45_70 VPWR VGND sg13g2_decap_8
XANTENNA_2 VPWR VGND digitalen.g\[3\].u.OUTN sg13g2_antennanp
XFILLER_31_389 VPWR VGND sg13g2_decap_8
Xclkbuf_4_14_0_clk clknet_0_clk clknet_4_14_0_clk VPWR VGND sg13g2_buf_8
XFILLER_8_574 VPWR VGND sg13g2_decap_8
XFILLER_6_53 VPWR VGND sg13g2_decap_8
XFILLER_39_434 VPWR VGND sg13g2_decap_8
X_0524_ _0208_ net68 _0303_ _0304_ VPWR VGND sg13g2_a21o_1
X_0455_ VPWR _0253_ daisychain\[60\] VGND sg13g2_inv_1
XFILLER_27_629 VPWR VGND sg13g2_decap_8
XFILLER_34_161 VPWR VGND sg13g2_decap_8
X_1007_ net119 VGND VPWR _0167_ state\[39\] clknet_5_13__leaf_clk sg13g2_dfrbpq_1
XFILLER_10_529 VPWR VGND sg13g2_decap_8
XFILLER_22_356 VPWR VGND sg13g2_decap_8
XFILLER_41_28 VPWR VGND sg13g2_decap_8
XFILLER_1_238 VPWR VGND sg13g2_decap_8
XFILLER_18_629 VPWR VGND sg13g2_fill_1
XFILLER_13_356 VPWR VGND sg13g2_decap_8
XFILLER_15_84 VPWR VGND sg13g2_decap_8
XFILLER_25_172 VPWR VGND sg13g2_decap_8
XFILLER_26_651 VPWR VGND sg13g2_decap_8
XFILLER_32_109 VPWR VGND sg13g2_decap_8
XFILLER_45_448 VPWR VGND sg13g2_decap_8
XFILLER_9_305 VPWR VGND sg13g2_decap_8
XFILLER_40_175 VPWR VGND sg13g2_decap_8
XFILLER_5_522 VPWR VGND sg13g2_decap_8
XFILLER_5_599 VPWR VGND sg13g2_decap_8
XFILLER_49_732 VPWR VGND sg13g2_decap_8
XFILLER_17_662 VPWR VGND sg13g2_decap_8
XFILLER_36_437 VPWR VGND sg13g2_decap_8
XFILLER_48_231 VPWR VGND sg13g2_decap_8
XFILLER_16_161 VPWR VGND sg13g2_decap_8
XFILLER_31_186 VPWR VGND sg13g2_decap_8
XFILLER_8_371 VPWR VGND sg13g2_decap_8
XFILLER_27_426 VPWR VGND sg13g2_decap_8
XFILLER_39_231 VPWR VGND sg13g2_decap_8
X_0507_ net87 VPWR _0291_ VGND net64 state\[11\] sg13g2_o21ai_1
XFILLER_23_643 VPWR VGND sg13g2_decap_8
XFILLER_10_326 VPWR VGND sg13g2_decap_8
XFILLER_22_153 VPWR VGND sg13g2_decap_8
XFILLER_6_319 VPWR VGND sg13g2_decap_8
XFILLER_2_536 VPWR VGND sg13g2_decap_8
XFILLER_18_437 VPWR VGND sg13g2_decap_8
XFILLER_45_245 VPWR VGND sg13g2_decap_8
XFILLER_46_724 VPWR VGND sg13g2_decap_8
XFILLER_13_153 VPWR VGND sg13g2_decap_8
XFILLER_33_429 VPWR VGND sg13g2_decap_8
XFILLER_41_462 VPWR VGND sg13g2_decap_8
XFILLER_9_102 VPWR VGND sg13g2_decap_8
XFILLER_9_179 VPWR VGND sg13g2_decap_8
XFILLER_5_396 VPWR VGND sg13g2_decap_8
XFILLER_3_32 VPWR VGND sg13g2_decap_8
XFILLER_36_267 VPWR VGND sg13g2_decap_8
XFILLER_32_473 VPWR VGND sg13g2_decap_8
X_0987_ net118 VGND VPWR _0147_ state\[19\] clknet_5_5__leaf_clk sg13g2_dfrbpq_1
Xclkbuf_5_28__f_clk clknet_5_28__leaf_clk clknet_4_14_0_clk VPWR VGND sg13g2_buf_16
Xfanout103 net112 net103 VPWR VGND sg13g2_buf_1
Xfanout114 net121 net114 VPWR VGND sg13g2_buf_1
XFILLER_27_223 VPWR VGND sg13g2_decap_8
XFILLER_43_727 VPWR VGND sg13g2_fill_1
XFILLER_47_49 VPWR VGND sg13g2_decap_8
XFILLER_10_123 VPWR VGND sg13g2_decap_8
XFILLER_23_440 VPWR VGND sg13g2_decap_8
XFILLER_42_259 VPWR VGND sg13g2_decap_8
XFILLER_11_668 VPWR VGND sg13g2_fill_1
XFILLER_12_74 VPWR VGND sg13g2_decap_8
XFILLER_6_116 VPWR VGND sg13g2_decap_8
XFILLER_2_333 VPWR VGND sg13g2_decap_8
XFILLER_14_440 VPWR VGND sg13g2_decap_8
XFILLER_18_234 VPWR VGND sg13g2_decap_8
XFILLER_27_790 VPWR VGND sg13g2_fill_1
XFILLER_33_226 VPWR VGND sg13g2_decap_8
XFILLER_37_82 VPWR VGND sg13g2_decap_8
XFILLER_46_532 VPWR VGND sg13g2_decap_8
X_0910_ net103 VGND VPWR _0070_ daisychain\[6\] clknet_5_22__leaf_clk sg13g2_dfrbpq_1
X_0841_ VPWR _0220_ daisychain\[27\] VGND sg13g2_inv_1
X_0772_ _0415_ VPWR _0180_ VGND net98 _0012_ sg13g2_o21ai_1
XFILLER_6_694 VPWR VGND sg13g2_fill_2
XFILLER_5_193 VPWR VGND sg13g2_decap_8
XFILLER_37_510 VPWR VGND sg13g2_decap_8
XFILLER_24_226 VPWR VGND sg13g2_decap_8
XFILLER_32_270 VPWR VGND sg13g2_decap_8
XFILLER_33_18 VPWR VGND sg13g2_decap_8
XFILLER_20_454 VPWR VGND sg13g2_decap_8
XFILLER_47_329 VPWR VGND sg13g2_decap_8
XFILLER_48_819 VPWR VGND sg13g2_decap_4
XFILLER_15_259 VPWR VGND sg13g2_decap_8
XFILLER_28_565 VPWR VGND sg13g2_decap_8
XFILLER_43_546 VPWR VGND sg13g2_decap_8
XFILLER_11_410 VPWR VGND sg13g2_decap_8
XFILLER_11_487 VPWR VGND sg13g2_decap_8
XFILLER_23_62 VPWR VGND sg13g2_decap_8
XFILLER_30_207 VPWR VGND sg13g2_decap_8
XFILLER_2_130 VPWR VGND sg13g2_decap_8
XFILLER_3_620 VPWR VGND sg13g2_decap_8
XFILLER_7_469 VPWR VGND sg13g2_decap_8
XFILLER_38_329 VPWR VGND sg13g2_decap_8
X_1040_ state\[56\] net7 VPWR VGND sg13g2_buf_1
Xclkbuf_5_11__f_clk clknet_5_11__leaf_clk clknet_4_5_0_clk VPWR VGND sg13g2_buf_16
XFILLER_48_70 VPWR VGND sg13g2_decap_8
XFILLER_0_77 VPWR VGND sg13g2_decap_8
XFILLER_34_546 VPWR VGND sg13g2_decap_8
XFILLER_9_53 VPWR VGND sg13g2_decap_8
X_0824_ VPWR _0042_ state\[19\] VGND sg13g2_inv_1
X_0755_ _0364_ VPWR _0163_ VGND net81 _0025_ sg13g2_o21ai_1
XFILLER_6_480 VPWR VGND sg13g2_decap_8
XFILLER_43_0 VPWR VGND sg13g2_decap_8
X_0686_ _0119_ _0424_ _0425_ net47 _0248_ VPWR VGND sg13g2_a22oi_1
XFILLER_25_557 VPWR VGND sg13g2_decap_8
XFILLER_37_362 VPWR VGND sg13g2_decap_4
XFILLER_44_28 VPWR VGND sg13g2_decap_8
XFILLER_12_207 VPWR VGND sg13g2_decap_8
XFILLER_20_251 VPWR VGND sg13g2_decap_8
XFILLER_33_590 VPWR VGND sg13g2_decap_4
XFILLER_4_417 VPWR VGND sg13g2_decap_8
XFILLER_0_623 VPWR VGND sg13g2_decap_8
XFILLER_47_126 VPWR VGND sg13g2_decap_8
XFILLER_48_616 VPWR VGND sg13g2_decap_8
XFILLER_16_546 VPWR VGND sg13g2_decap_8
XFILLER_18_73 VPWR VGND sg13g2_decap_8
XFILLER_28_362 VPWR VGND sg13g2_decap_8
XFILLER_43_343 VPWR VGND sg13g2_decap_8
XFILLER_11_284 VPWR VGND sg13g2_decap_8
XFILLER_12_741 VPWR VGND sg13g2_fill_2
XFILLER_8_701 VPWR VGND sg13g2_fill_1
XFILLER_7_266 VPWR VGND sg13g2_decap_8
XFILLER_3_494 VPWR VGND sg13g2_decap_8
X_0540_ _0212_ net74 _0315_ _0316_ VPWR VGND sg13g2_a21o_1
X_0471_ net82 VPWR _0264_ VGND net59 state\[2\] sg13g2_o21ai_1
XFILLER_15_4 VPWR VGND sg13g2_decap_4
XFILLER_19_351 VPWR VGND sg13g2_decap_8
XFILLER_34_343 VPWR VGND sg13g2_decap_8
XFILLER_38_126 VPWR VGND sg13g2_decap_8
XFILLER_47_693 VPWR VGND sg13g2_decap_8
X_1023_ net116 VGND VPWR _0183_ state\[55\] clknet_5_11__leaf_clk sg13g2_dfrbpq_1
XFILLER_22_538 VPWR VGND sg13g2_decap_8
X_0807_ VPWR _0203_ daisychain\[10\] VGND sg13g2_inv_1
X_0738_ _0313_ VPWR _0146_ VGND net91 _0041_ sg13g2_o21ai_1
XFILLER_29_159 VPWR VGND sg13g2_decap_8
XFILLER_39_28 VPWR VGND sg13g2_decap_8
X_0669_ VGND VPWR net30 daisychain\[50\] _0413_ net52 sg13g2_a21oi_1
XFILLER_13_538 VPWR VGND sg13g2_decap_8
XFILLER_25_354 VPWR VGND sg13g2_decap_8
XFILLER_26_822 VPWR VGND sg13g2_fill_1
XFILLER_40_357 VPWR VGND sg13g2_decap_8
XFILLER_4_214 VPWR VGND sg13g2_decap_8
XFILLER_0_420 VPWR VGND sg13g2_decap_8
XFILLER_20_41 VPWR VGND sg13g2_decap_8
XFILLER_0_497 VPWR VGND sg13g2_decap_8
XFILLER_29_61 VPWR VGND sg13g2_decap_8
XFILLER_35_118 VPWR VGND sg13g2_decap_8
XFILLER_44_630 VPWR VGND sg13g2_decap_8
XFILLER_48_413 VPWR VGND sg13g2_decap_8
XFILLER_16_343 VPWR VGND sg13g2_decap_8
XFILLER_31_368 VPWR VGND sg13g2_decap_8
XFILLER_43_140 VPWR VGND sg13g2_decap_8
XFILLER_44_674 VPWR VGND sg13g2_decap_8
XANTENNA_3 VPWR VGND state\[1\] sg13g2_antennanp
Xclkbuf_5_9__f_clk clknet_5_9__leaf_clk clknet_4_4_0_clk VPWR VGND sg13g2_buf_16
XFILLER_8_553 VPWR VGND sg13g2_decap_8
XFILLER_6_32 VPWR VGND sg13g2_decap_8
XFILLER_27_608 VPWR VGND sg13g2_decap_8
XFILLER_39_413 VPWR VGND sg13g2_decap_8
XFILLER_3_291 VPWR VGND sg13g2_decap_8
X_0523_ net88 VPWR _0303_ VGND net68 state\[15\] sg13g2_o21ai_1
X_0454_ VPWR _0020_ state\[60\] VGND sg13g2_inv_1
XFILLER_34_140 VPWR VGND sg13g2_decap_8
XFILLER_47_490 VPWR VGND sg13g2_decap_8
X_1006_ net116 VGND VPWR _0166_ state\[38\] clknet_5_12__leaf_clk sg13g2_dfrbpq_1
XFILLER_10_508 VPWR VGND sg13g2_decap_8
XFILLER_22_335 VPWR VGND sg13g2_decap_8
XFILLER_1_217 VPWR VGND sg13g2_decap_8
XFILLER_2_718 VPWR VGND sg13g2_fill_2
XFILLER_17_129 VPWR VGND sg13g2_decap_8
XFILLER_26_630 VPWR VGND sg13g2_decap_8
XFILLER_45_427 VPWR VGND sg13g2_decap_8
XFILLER_13_335 VPWR VGND sg13g2_decap_8
XFILLER_15_63 VPWR VGND sg13g2_decap_8
XFILLER_25_151 VPWR VGND sg13g2_decap_8
XFILLER_26_685 VPWR VGND sg13g2_decap_8
XFILLER_26_696 VPWR VGND sg13g2_fill_2
XFILLER_40_154 VPWR VGND sg13g2_decap_8
XFILLER_41_633 VPWR VGND sg13g2_decap_8
XFILLER_31_95 VPWR VGND sg13g2_decap_8
XFILLER_5_578 VPWR VGND sg13g2_decap_8
XFILLER_5_501 VPWR VGND sg13g2_decap_8
XFILLER_0_294 VPWR VGND sg13g2_decap_8
XFILLER_48_210 VPWR VGND sg13g2_decap_8
XFILLER_49_711 VPWR VGND sg13g2_decap_8
XFILLER_16_140 VPWR VGND sg13g2_decap_8
XFILLER_17_696 VPWR VGND sg13g2_decap_8
XFILLER_36_416 VPWR VGND sg13g2_decap_8
XFILLER_48_287 VPWR VGND sg13g2_decap_8
XFILLER_49_788 VPWR VGND sg13g2_decap_8
XFILLER_31_165 VPWR VGND sg13g2_decap_8
XFILLER_32_644 VPWR VGND sg13g2_fill_1
XFILLER_8_350 VPWR VGND sg13g2_decap_8
X_0506_ _0074_ _0289_ _0290_ net40 _0203_ VPWR VGND sg13g2_a22oi_1
XFILLER_27_405 VPWR VGND sg13g2_decap_8
XFILLER_39_210 VPWR VGND sg13g2_decap_8
XFILLER_39_287 VPWR VGND sg13g2_decap_8
XFILLER_10_305 VPWR VGND sg13g2_decap_8
XFILLER_22_132 VPWR VGND sg13g2_decap_8
XFILLER_23_622 VPWR VGND sg13g2_decap_8
XFILLER_23_677 VPWR VGND sg13g2_fill_2
XFILLER_35_482 VPWR VGND sg13g2_decap_8
XFILLER_2_515 VPWR VGND sg13g2_decap_8
Xclkbuf_4_13_0_clk clknet_0_clk clknet_4_13_0_clk VPWR VGND sg13g2_buf_8
XFILLER_18_416 VPWR VGND sg13g2_decap_8
XFILLER_26_84 VPWR VGND sg13g2_decap_8
XFILLER_33_408 VPWR VGND sg13g2_decap_8
XFILLER_45_224 VPWR VGND sg13g2_decap_8
XFILLER_46_758 VPWR VGND sg13g2_decap_4
XFILLER_13_132 VPWR VGND sg13g2_decap_8
XFILLER_41_441 VPWR VGND sg13g2_decap_8
XFILLER_9_158 VPWR VGND sg13g2_decap_8
XFILLER_3_11 VPWR VGND sg13g2_decap_8
XFILLER_47_7 VPWR VGND sg13g2_decap_8
XFILLER_5_375 VPWR VGND sg13g2_decap_8
XFILLER_1_581 VPWR VGND sg13g2_decap_8
XFILLER_37_703 VPWR VGND sg13g2_decap_4
XFILLER_3_88 VPWR VGND sg13g2_decap_8
XFILLER_49_585 VPWR VGND sg13g2_decap_8
XFILLER_17_493 VPWR VGND sg13g2_decap_8
XFILLER_20_603 VPWR VGND sg13g2_fill_2
XFILLER_24_408 VPWR VGND sg13g2_decap_4
XFILLER_32_452 VPWR VGND sg13g2_decap_8
XFILLER_36_246 VPWR VGND sg13g2_decap_8
X_0986_ net110 VGND VPWR _0146_ state\[18\] clknet_5_31__leaf_clk sg13g2_dfrbpq_1
XFILLER_47_28 VPWR VGND sg13g2_decap_8
Xfanout104 net112 net104 VPWR VGND sg13g2_buf_1
Xfanout115 net121 net115 VPWR VGND sg13g2_buf_1
XFILLER_27_202 VPWR VGND sg13g2_decap_8
XFILLER_27_279 VPWR VGND sg13g2_decap_8
XFILLER_10_102 VPWR VGND sg13g2_decap_8
XFILLER_11_614 VPWR VGND sg13g2_decap_4
XFILLER_23_496 VPWR VGND sg13g2_decap_8
XFILLER_42_238 VPWR VGND sg13g2_decap_8
XFILLER_7_618 VPWR VGND sg13g2_fill_1
XFILLER_10_179 VPWR VGND sg13g2_decap_8
XFILLER_12_53 VPWR VGND sg13g2_decap_8
XFILLER_2_312 VPWR VGND sg13g2_decap_8
XFILLER_18_213 VPWR VGND sg13g2_decap_8
XFILLER_2_389 VPWR VGND sg13g2_decap_8
XFILLER_46_511 VPWR VGND sg13g2_decap_8
XFILLER_33_205 VPWR VGND sg13g2_decap_8
XFILLER_37_61 VPWR VGND sg13g2_decap_8
XFILLER_46_588 VPWR VGND sg13g2_decap_8
XFILLER_14_496 VPWR VGND sg13g2_decap_8
X_0840_ VPWR _0051_ state\[27\] VGND sg13g2_inv_1
X_0771_ _0412_ VPWR _0179_ VGND net97 _0010_ sg13g2_o21ai_1
XFILLER_5_172 VPWR VGND sg13g2_decap_8
XFILLER_24_205 VPWR VGND sg13g2_decap_8
XFILLER_37_566 VPWR VGND sg13g2_decap_8
XFILLER_49_382 VPWR VGND sg13g2_decap_8
XFILLER_17_290 VPWR VGND sg13g2_decap_8
XFILLER_20_433 VPWR VGND sg13g2_decap_8
XFILLER_3_109 VPWR VGND sg13g2_decap_8
X_0969_ net103 VGND VPWR _0129_ state\[1\] clknet_5_22__leaf_clk sg13g2_dfrbpq_1
XFILLER_47_308 VPWR VGND sg13g2_decap_8
XFILLER_15_238 VPWR VGND sg13g2_decap_8
XFILLER_28_544 VPWR VGND sg13g2_decap_8
XFILLER_43_525 VPWR VGND sg13g2_decap_8
XFILLER_11_466 VPWR VGND sg13g2_decap_8
XFILLER_23_293 VPWR VGND sg13g2_decap_8
XFILLER_7_448 VPWR VGND sg13g2_decap_8
XFILLER_2_186 VPWR VGND sg13g2_decap_8
XFILLER_0_56 VPWR VGND sg13g2_decap_8
XFILLER_19_533 VPWR VGND sg13g2_decap_4
XFILLER_34_525 VPWR VGND sg13g2_decap_8
XFILLER_38_308 VPWR VGND sg13g2_decap_8
XFILLER_46_385 VPWR VGND sg13g2_decap_8
XFILLER_14_293 VPWR VGND sg13g2_decap_8
XFILLER_9_32 VPWR VGND sg13g2_decap_8
X_0823_ VPWR _0211_ daisychain\[18\] VGND sg13g2_inv_1
X_0754_ _0361_ VPWR _0162_ VGND net94 _0022_ sg13g2_o21ai_1
X_0685_ VGND VPWR net31 daisychain\[54\] _0425_ net48 sg13g2_a21oi_1
XFILLER_36_0 VPWR VGND sg13g2_decap_8
XFILLER_25_536 VPWR VGND sg13g2_decap_8
XFILLER_37_341 VPWR VGND sg13g2_decap_8
XFILLER_20_230 VPWR VGND sg13g2_decap_8
XFILLER_21_797 VPWR VGND sg13g2_fill_1
XFILLER_40_539 VPWR VGND sg13g2_decap_8
XFILLER_0_602 VPWR VGND sg13g2_decap_8
XFILLER_0_679 VPWR VGND sg13g2_decap_8
XFILLER_16_525 VPWR VGND sg13g2_decap_8
XFILLER_18_52 VPWR VGND sg13g2_decap_8
XFILLER_28_341 VPWR VGND sg13g2_decap_8
XFILLER_44_812 VPWR VGND sg13g2_decap_8
XFILLER_47_105 VPWR VGND sg13g2_decap_8
XFILLER_24_580 VPWR VGND sg13g2_decap_8
XFILLER_34_84 VPWR VGND sg13g2_decap_8
XFILLER_43_322 VPWR VGND sg13g2_decap_8
XFILLER_43_399 VPWR VGND sg13g2_decap_8
XFILLER_11_263 VPWR VGND sg13g2_decap_8
XFILLER_8_779 VPWR VGND sg13g2_decap_4
XFILLER_7_245 VPWR VGND sg13g2_decap_8
XFILLER_38_105 VPWR VGND sg13g2_decap_8
XFILLER_3_473 VPWR VGND sg13g2_decap_8
X_0470_ _0065_ _0262_ _0263_ net36 _0194_ VPWR VGND sg13g2_a22oi_1
XFILLER_19_330 VPWR VGND sg13g2_decap_8
XFILLER_22_517 VPWR VGND sg13g2_decap_8
XFILLER_34_322 VPWR VGND sg13g2_decap_8
XFILLER_46_182 VPWR VGND sg13g2_decap_8
XFILLER_47_672 VPWR VGND sg13g2_decap_8
X_1022_ net116 VGND VPWR _0182_ state\[54\] clknet_5_12__leaf_clk sg13g2_dfrbpq_1
XFILLER_30_550 VPWR VGND sg13g2_decap_4
XFILLER_34_399 VPWR VGND sg13g2_decap_8
X_0806_ VPWR _0033_ state\[10\] VGND sg13g2_inv_1
X_0737_ _0310_ VPWR _0145_ VGND net90 _0040_ sg13g2_o21ai_1
X_0668_ _0244_ net75 _0411_ _0412_ VPWR VGND sg13g2_a21o_1
XFILLER_29_138 VPWR VGND sg13g2_decap_8
XFILLER_44_119 VPWR VGND sg13g2_decap_8
XFILLER_45_609 VPWR VGND sg13g2_decap_8
X_0599_ net94 VPWR _0360_ VGND net69 state\[34\] sg13g2_o21ai_1
XFILLER_13_517 VPWR VGND sg13g2_decap_8
XFILLER_25_333 VPWR VGND sg13g2_decap_8
XFILLER_40_336 VPWR VGND sg13g2_decap_8
XFILLER_21_583 VPWR VGND sg13g2_decap_8
XFILLER_0_476 VPWR VGND sg13g2_decap_8
XFILLER_20_97 VPWR VGND sg13g2_decap_8
XFILLER_29_40 VPWR VGND sg13g2_decap_8
XFILLER_16_322 VPWR VGND sg13g2_decap_8
XFILLER_48_469 VPWR VGND sg13g2_decap_8
XFILLER_12_550 VPWR VGND sg13g2_decap_8
XFILLER_16_399 VPWR VGND sg13g2_decap_8
XFILLER_31_347 VPWR VGND sg13g2_decap_8
XFILLER_43_196 VPWR VGND sg13g2_decap_8
XFILLER_8_532 VPWR VGND sg13g2_decap_8
XANTENNA_4 VPWR VGND state\[5\] sg13g2_antennanp
XFILLER_3_270 VPWR VGND sg13g2_decap_8
X_0522_ _0078_ _0301_ _0302_ net41 _0207_ VPWR VGND sg13g2_a22oi_1
XFILLER_6_88 VPWR VGND sg13g2_decap_8
XFILLER_6_11 VPWR VGND sg13g2_decap_8
XFILLER_26_119 VPWR VGND sg13g2_decap_8
XFILLER_39_469 VPWR VGND sg13g2_decap_8
X_0453_ VPWR _0252_ daisychain\[59\] VGND sg13g2_inv_1
XFILLER_22_314 VPWR VGND sg13g2_decap_8
XFILLER_23_804 VPWR VGND sg13g2_decap_8
XFILLER_34_196 VPWR VGND sg13g2_decap_8
XFILLER_35_653 VPWR VGND sg13g2_fill_1
XFILLER_35_664 VPWR VGND sg13g2_fill_2
X_1005_ net114 VGND VPWR _0165_ state\[37\] clknet_5_2__leaf_clk sg13g2_dfrbpq_1
XFILLER_17_108 VPWR VGND sg13g2_decap_8
XFILLER_25_130 VPWR VGND sg13g2_decap_8
XFILLER_45_406 VPWR VGND sg13g2_decap_8
XFILLER_13_314 VPWR VGND sg13g2_decap_8
XFILLER_15_42 VPWR VGND sg13g2_decap_8
XFILLER_40_133 VPWR VGND sg13g2_decap_8
XFILLER_31_74 VPWR VGND sg13g2_decap_8
XFILLER_5_557 VPWR VGND sg13g2_decap_8
XFILLER_0_273 VPWR VGND sg13g2_decap_8
XFILLER_1_785 VPWR VGND sg13g2_decap_4
XFILLER_48_266 VPWR VGND sg13g2_decap_8
XFILLER_49_767 VPWR VGND sg13g2_decap_8
XFILLER_16_196 VPWR VGND sg13g2_decap_8
XFILLER_17_620 VPWR VGND sg13g2_fill_2
XFILLER_17_631 VPWR VGND sg13g2_decap_8
XFILLER_32_634 VPWR VGND sg13g2_fill_1
XFILLER_44_483 VPWR VGND sg13g2_decap_8
XFILLER_31_144 VPWR VGND sg13g2_decap_8
X_0505_ VGND VPWR net25 daisychain\[9\] _0290_ net40 sg13g2_a21oi_1
.ends

* NGSPICE file created from heichips25_pudding.ext - technology: ihp-sg13g2

* Black-box entry subcircuit for sg13g2_decap_8 abstract view
.subckt sg13g2_decap_8 VDD VSS
.ends

* Black-box entry subcircuit for sg13g2_dfrbpq_1 abstract view
.subckt sg13g2_dfrbpq_1 RESET_B VSS VDD D Q CLK
.ends

* Black-box entry subcircuit for sg13g2_buf_1 abstract view
.subckt sg13g2_buf_1 A X VDD VSS
.ends

* Black-box entry subcircuit for sg13g2_decap_4 abstract view
.subckt sg13g2_decap_4 VDD VSS
.ends

* Black-box entry subcircuit for sg13g2_fill_1 abstract view
.subckt sg13g2_fill_1 VDD VSS
.ends

* Black-box entry subcircuit for sg13g2_o21ai_1 abstract view
.subckt sg13g2_o21ai_1 B1 VDD Y VSS A1 A2
.ends

* Black-box entry subcircuit for sg13g2_buf_8 abstract view
.subckt sg13g2_buf_8 A X VDD VSS
.ends

* Black-box entry subcircuit for sg13g2_inv_1 abstract view
.subckt sg13g2_inv_1 VDD Y A VSS
.ends

* Black-box entry subcircuit for sg13g2_fill_2 abstract view
.subckt sg13g2_fill_2 VDD VSS
.ends

* Black-box entry subcircuit for sg13g2_a21o_1 abstract view
.subckt sg13g2_a21o_1 A2 A1 B1 X VDD VSS
.ends

* Black-box entry subcircuit for sg13g2_a22oi_1 abstract view
.subckt sg13g2_a22oi_1 Y B1 B2 A2 A1 VDD VSS
.ends

* Black-box entry subcircuit for sg13g2_a21oi_1 abstract view
.subckt sg13g2_a21oi_1 VSS VDD A1 A2 Y B1
.ends

* Black-box entry subcircuit for sg13g2_buf_16 abstract view
.subckt sg13g2_buf_16 X A VDD VSS
.ends

* Black-box entry subcircuit for sg13g2_or2_1 abstract view
.subckt sg13g2_or2_1 VSS VDD X B A
.ends

* Black-box entry subcircuit for sg13g2_nor2b_1 abstract view
.subckt sg13g2_nor2b_1 A B_N Y VDD VSS
.ends

* Black-box entry subcircuit for sg13g2_nand2_1 abstract view
.subckt sg13g2_nand2_1 Y A B VDD VSS
.ends

* Black-box entry subcircuit for sg13g2_nor2_1 abstract view
.subckt sg13g2_nor2_1 A B Y VDD VSS
.ends

* Black-box entry subcircuit for sg13g2_tiehi abstract view
.subckt sg13g2_tiehi VDD VSS L_HI
.ends

* Black-box entry subcircuit for analog_wires abstract view
.subckt analog_wires VcascP[0] VcascP[1] Iout[0] VDDA[0] VDDA[1] VbiasP[1] VbiasP[0]
+ VcascP[2] VcascP[3] Iout[1] VDDA[2] VDDA[3] VbiasP[3] VbiasP[2] i_in i_out
.ends

* Black-box entry subcircuit for dac32module abstract view
.subckt dac32module EN[1] ENB[1] EN[2] ENB[2] ON[16] ONB[16] ON[17] ONB[17] ON[18]
+ ONB[18] ON[19] ONB[19] ON[20] ONB[20] ON[21] ONB[21] ON[22] ONB[22] ON[23] ONB[23]
+ ON[24] ONB[24] ON[25] ONB[25] ON[26] ONB[26] ON[27] ONB[27] ON[28] ONB[28] ON[29]
+ ONB[29] ON[30] ONB[30] ON[31] ONB[31] EN[3] ENB[3] ON[0] ONB[0] ON[1] ONB[1] ON[2]
+ ONB[2] ON[3] ONB[3] ON[4] ONB[4] ON[5] ONB[5] ON[6] EN[0] ENB[0] ONB[6] ON[7] ONB[7]
+ ON[8] ONB[8] ON[9] ONB[9] ON[10] ONB[10] ON[11] ONB[11] ON[12] ONB[12] ON[13] ONB[13]
+ ON[14] ONB[14] ON[15] ONB[15] Iout VbiasP[0] VbiasP[1] VcascP[1] VcascP[0] VDD VSS
.ends

* Black-box entry subcircuit for sg13g2_antennanp abstract view
.subckt sg13g2_antennanp VDD VSS A
.ends

.subckt heichips25_pudding VGND VPWR clk ena i_in i_out rst_n ui_in[0] ui_in[1] ui_in[2]
+ ui_in[3] ui_in[4] ui_in[5] ui_in[6] ui_in[7] uio_in[0] uio_in[1] uio_in[2] uio_in[3]
+ uio_in[4] uio_in[5] uio_in[6] uio_in[7] uio_oe[0] uio_oe[1] uio_oe[2] uio_oe[3]
+ uio_oe[4] uio_oe[5] uio_oe[6] uio_oe[7] uio_out[0] uio_out[1] uio_out[2] uio_out[3]
+ uio_out[4] uio_out[5] uio_out[6] uio_out[7] uo_out[0] uo_out[1] uo_out[2] uo_out[3]
+ uo_out[4] uo_out[5] uo_out[6] uo_out[7]
XFILLER_27_406 VPWR VGND sg13g2_decap_8
XFILLER_39_266 VPWR VGND sg13g2_decap_8
XFILLER_10_328 VPWR VGND sg13g2_decap_8
XFILLER_22_133 VPWR VGND sg13g2_decap_8
XFILLER_23_612 VPWR VGND sg13g2_decap_8
XFILLER_23_689 VPWR VGND sg13g2_decap_8
XFILLER_35_483 VPWR VGND sg13g2_decap_8
XFILLER_7_7 VPWR VGND sg13g2_decap_8
XFILLER_13_111 VPWR VGND sg13g2_decap_8
XFILLER_26_96 VPWR VGND sg13g2_decap_8
XFILLER_45_225 VPWR VGND sg13g2_decap_8
XFILLER_13_188 VPWR VGND sg13g2_decap_8
XFILLER_41_475 VPWR VGND sg13g2_decap_8
XFILLER_42_40 VPWR VGND sg13g2_decap_8
XFILLER_9_137 VPWR VGND sg13g2_decap_8
XFILLER_1_560 VPWR VGND sg13g2_decap_8
XFILLER_5_354 VPWR VGND sg13g2_decap_8
XFILLER_36_203 VPWR VGND sg13g2_decap_8
XFILLER_3_67 VPWR VGND sg13g2_decap_8
XFILLER_49_564 VPWR VGND sg13g2_decap_8
XFILLER_20_626 VPWR VGND sg13g2_decap_8
XFILLER_32_431 VPWR VGND sg13g2_decap_8
X_0985_ net108 VGND VPWR _0145_ state\[17\] clknet_5_0__leaf_clk sg13g2_dfrbpq_1
XFILLER_8_181 VPWR VGND sg13g2_decap_8
Xfanout105 net106 net105 VPWR VGND sg13g2_buf_1
Xfanout116 net117 net116 VPWR VGND sg13g2_buf_1
XFILLER_27_203 VPWR VGND sg13g2_decap_8
XFILLER_28_726 VPWR VGND sg13g2_decap_8
XFILLER_35_280 VPWR VGND sg13g2_decap_8
XFILLER_42_217 VPWR VGND sg13g2_decap_8
XFILLER_43_707 VPWR VGND sg13g2_decap_8
XFILLER_10_125 VPWR VGND sg13g2_decap_8
XFILLER_11_604 VPWR VGND sg13g2_decap_4
XFILLER_23_486 VPWR VGND sg13g2_decap_8
XFILLER_7_619 VPWR VGND sg13g2_decap_8
XFILLER_12_76 VPWR VGND sg13g2_decap_8
XFILLER_2_368 VPWR VGND sg13g2_decap_8
XFILLER_5_4 VPWR VGND sg13g2_decap_8
XFILLER_18_258 VPWR VGND sg13g2_decap_8
XFILLER_19_726 VPWR VGND sg13g2_fill_1
XFILLER_37_84 VPWR VGND sg13g2_decap_8
XFILLER_46_567 VPWR VGND sg13g2_decap_8
XFILLER_14_453 VPWR VGND sg13g2_decap_8
XFILLER_33_228 VPWR VGND sg13g2_decap_8
XFILLER_41_272 VPWR VGND sg13g2_decap_8
X_0770_ _0409_ VPWR _0178_ VGND net97 _0009_ sg13g2_o21ai_1
XFILLER_5_151 VPWR VGND sg13g2_decap_8
XFILLER_24_217 VPWR VGND sg13g2_decap_8
XFILLER_25_718 VPWR VGND sg13g2_decap_8
XFILLER_37_567 VPWR VGND sg13g2_decap_8
XFILLER_49_361 VPWR VGND sg13g2_decap_8
XFILLER_20_423 VPWR VGND sg13g2_decap_8
X_0968_ net105 VGND VPWR _0128_ state\[0\] clknet_5_9__leaf_clk sg13g2_dfrbpq_1
Xclkbuf_4_12_0_clk clknet_0_clk clknet_4_12_0_clk VPWR VGND sg13g2_buf_8
X_0899_ VPWR _0249_ daisychain\[56\] VGND sg13g2_inv_1
XFILLER_28_545 VPWR VGND sg13g2_decap_8
XFILLER_23_283 VPWR VGND sg13g2_decap_8
XFILLER_24_751 VPWR VGND sg13g2_decap_4
XFILLER_30_209 VPWR VGND sg13g2_decap_8
XFILLER_43_526 VPWR VGND sg13g2_decap_8
XFILLER_23_31 VPWR VGND sg13g2_fill_2
XFILLER_7_427 VPWR VGND sg13g2_decap_8
XFILLER_2_165 VPWR VGND sg13g2_decap_8
XFILLER_0_35 VPWR VGND sg13g2_decap_8
XFILLER_19_567 VPWR VGND sg13g2_decap_8
XFILLER_34_515 VPWR VGND sg13g2_decap_8
XFILLER_46_364 VPWR VGND sg13g2_decap_8
XFILLER_14_250 VPWR VGND sg13g2_decap_8
XFILLER_30_776 VPWR VGND sg13g2_decap_8
XFILLER_30_787 VPWR VGND sg13g2_fill_1
X_0822_ VPWR _0041_ state\[18\] VGND sg13g2_inv_1
XFILLER_9_88 VPWR VGND sg13g2_decap_8
XFILLER_9_11 VPWR VGND sg13g2_decap_8
X_0753_ _0358_ VPWR _0161_ VGND net93 _0011_ sg13g2_o21ai_1
X_0684_ _0248_ net70 _0423_ _0424_ VPWR VGND sg13g2_a21o_1
XFILLER_12_209 VPWR VGND sg13g2_decap_8
XFILLER_25_515 VPWR VGND sg13g2_decap_8
XFILLER_37_364 VPWR VGND sg13g2_decap_8
XFILLER_20_220 VPWR VGND sg13g2_decap_8
XFILLER_20_297 VPWR VGND sg13g2_decap_8
XFILLER_21_776 VPWR VGND sg13g2_fill_2
XFILLER_33_592 VPWR VGND sg13g2_decap_8
XFILLER_4_419 VPWR VGND sg13g2_decap_8
XFILLER_16_515 VPWR VGND sg13g2_decap_8
XFILLER_18_97 VPWR VGND sg13g2_decap_8
XFILLER_28_342 VPWR VGND sg13g2_decap_8
XFILLER_11_242 VPWR VGND sg13g2_decap_8
XFILLER_12_710 VPWR VGND sg13g2_fill_2
XFILLER_24_581 VPWR VGND sg13g2_decap_8
XFILLER_34_74 VPWR VGND sg13g2_decap_8
XFILLER_43_367 VPWR VGND sg13g2_decap_8
XFILLER_3_452 VPWR VGND sg13g2_decap_8
XFILLER_7_224 VPWR VGND sg13g2_decap_8
XFILLER_39_607 VPWR VGND sg13g2_decap_8
XFILLER_19_364 VPWR VGND sg13g2_decap_8
XFILLER_22_518 VPWR VGND sg13g2_decap_8
XFILLER_34_312 VPWR VGND sg13g2_decap_8
XFILLER_34_389 VPWR VGND sg13g2_decap_8
XFILLER_46_161 VPWR VGND sg13g2_decap_8
X_1021_ net113 VGND VPWR _0181_ state\[53\] clknet_5_30__leaf_clk sg13g2_dfrbpq_1
XFILLER_30_573 VPWR VGND sg13g2_decap_8
X_0805_ VPWR _0202_ daisychain\[9\] VGND sg13g2_inv_1
X_0736_ _0307_ VPWR _0144_ VGND net86 _0039_ sg13g2_o21ai_1
X_0667_ net96 VPWR _0411_ VGND net74 state\[51\] sg13g2_o21ai_1
X_0598_ _0097_ _0358_ _0359_ net49 _0226_ VPWR VGND sg13g2_a22oi_1
XFILLER_29_139 VPWR VGND sg13g2_decap_8
XFILLER_37_161 VPWR VGND sg13g2_decap_8
XFILLER_38_651 VPWR VGND sg13g2_fill_1
XFILLER_38_684 VPWR VGND sg13g2_decap_8
XFILLER_13_507 VPWR VGND sg13g2_decap_8
XFILLER_25_356 VPWR VGND sg13g2_decap_8
XFILLER_21_584 VPWR VGND sg13g2_decap_8
XFILLER_4_216 VPWR VGND sg13g2_decap_8
XFILLER_0_455 VPWR VGND sg13g2_decap_8
XFILLER_20_87 VPWR VGND sg13g2_decap_8
XFILLER_29_41 VPWR VGND sg13g2_decap_8
XFILLER_48_448 VPWR VGND sg13g2_decap_8
XFILLER_16_312 VPWR VGND sg13g2_decap_8
XFILLER_16_389 VPWR VGND sg13g2_decap_8
XFILLER_17_813 VPWR VGND sg13g2_decap_8
XFILLER_29_684 VPWR VGND sg13g2_decap_8
XFILLER_43_164 VPWR VGND sg13g2_decap_8
XFILLER_31_337 VPWR VGND sg13g2_decap_8
XFILLER_8_566 VPWR VGND sg13g2_decap_8
X_0521_ VGND VPWR net27 daisychain\[13\] _0302_ net41 sg13g2_a21oi_1
X_0452_ VPWR _0019_ state\[59\] VGND sg13g2_inv_1
XFILLER_6_67 VPWR VGND sg13g2_decap_8
XFILLER_19_161 VPWR VGND sg13g2_decap_8
XFILLER_20_4 VPWR VGND sg13g2_decap_4
XFILLER_39_448 VPWR VGND sg13g2_decap_8
XFILLER_22_315 VPWR VGND sg13g2_decap_8
XFILLER_34_186 VPWR VGND sg13g2_decap_8
XFILLER_35_687 VPWR VGND sg13g2_fill_1
X_1004_ net112 VGND VPWR _0164_ state\[36\] clknet_5_24__leaf_clk sg13g2_dfrbpq_1
XFILLER_30_370 VPWR VGND sg13g2_decap_8
X_0719_ _0127_ _0449_ _0450_ net35 _0256_ VPWR VGND sg13g2_a22oi_1
XFILLER_25_153 VPWR VGND sg13g2_decap_8
XFILLER_26_621 VPWR VGND sg13g2_decap_8
XFILLER_26_698 VPWR VGND sg13g2_decap_8
XFILLER_45_407 VPWR VGND sg13g2_decap_8
XFILLER_15_65 VPWR VGND sg13g2_decap_8
XFILLER_21_381 VPWR VGND sg13g2_decap_8
XFILLER_40_145 VPWR VGND sg13g2_decap_8
XFILLER_41_635 VPWR VGND sg13g2_decap_8
XFILLER_9_319 VPWR VGND sg13g2_decap_8
XFILLER_31_64 VPWR VGND sg13g2_decap_8
Xoutput20 net20 uo_out[4] VPWR VGND sg13g2_buf_1
XFILLER_5_536 VPWR VGND sg13g2_decap_8
XFILLER_0_252 VPWR VGND sg13g2_decap_8
XFILLER_17_610 VPWR VGND sg13g2_decap_8
XFILLER_49_768 VPWR VGND sg13g2_fill_1
XFILLER_49_757 VPWR VGND sg13g2_decap_8
XFILLER_48_245 VPWR VGND sg13g2_decap_8
XFILLER_16_186 VPWR VGND sg13g2_decap_8
XFILLER_31_134 VPWR VGND sg13g2_decap_8
XFILLER_32_613 VPWR VGND sg13g2_decap_8
XFILLER_44_473 VPWR VGND sg13g2_decap_8
XFILLER_12_370 VPWR VGND sg13g2_decap_8
Xclkbuf_5_17__f_clk clknet_5_17__leaf_clk clknet_4_8_0_clk VPWR VGND sg13g2_buf_16
XFILLER_8_363 VPWR VGND sg13g2_decap_8
X_0504_ _0203_ net63 _0288_ _0289_ VPWR VGND sg13g2_a21o_1
XFILLER_35_462 VPWR VGND sg13g2_decap_8
XFILLER_39_245 VPWR VGND sg13g2_decap_8
XFILLER_10_307 VPWR VGND sg13g2_decap_8
XFILLER_22_112 VPWR VGND sg13g2_decap_8
XFILLER_22_189 VPWR VGND sg13g2_decap_8
XFILLER_23_668 VPWR VGND sg13g2_decap_8
XFILLER_45_204 VPWR VGND sg13g2_decap_8
XFILLER_13_167 VPWR VGND sg13g2_decap_8
XFILLER_14_646 VPWR VGND sg13g2_fill_1
XFILLER_26_20 VPWR VGND sg13g2_decap_8
XFILLER_26_495 VPWR VGND sg13g2_decap_8
XFILLER_26_75 VPWR VGND sg13g2_decap_8
XFILLER_41_454 VPWR VGND sg13g2_decap_8
XFILLER_9_116 VPWR VGND sg13g2_decap_8
XFILLER_42_96 VPWR VGND sg13g2_decap_8
XFILLER_5_333 VPWR VGND sg13g2_decap_8
XFILLER_1_583 VPWR VGND sg13g2_fill_2
XFILLER_3_46 VPWR VGND sg13g2_decap_8
XFILLER_36_259 VPWR VGND sg13g2_decap_8
XFILLER_49_543 VPWR VGND sg13g2_decap_8
XFILLER_17_484 VPWR VGND sg13g2_decap_8
XFILLER_20_605 VPWR VGND sg13g2_decap_8
XFILLER_32_410 VPWR VGND sg13g2_decap_8
XFILLER_32_487 VPWR VGND sg13g2_decap_8
XFILLER_44_292 VPWR VGND sg13g2_decap_8
X_0984_ net108 VGND VPWR _0144_ state\[16\] clknet_5_0__leaf_clk sg13g2_dfrbpq_1
XFILLER_8_160 VPWR VGND sg13g2_decap_8
XFILLER_28_705 VPWR VGND sg13g2_decap_8
Xfanout106 net118 net106 VPWR VGND sg13g2_buf_1
Xfanout117 net118 net117 VPWR VGND sg13g2_buf_1
XFILLER_23_465 VPWR VGND sg13g2_decap_8
XFILLER_27_259 VPWR VGND sg13g2_decap_8
XFILLER_10_104 VPWR VGND sg13g2_decap_8
XFILLER_12_55 VPWR VGND sg13g2_decap_8
XFILLER_2_347 VPWR VGND sg13g2_decap_8
XFILLER_18_237 VPWR VGND sg13g2_decap_8
XFILLER_33_207 VPWR VGND sg13g2_decap_8
XFILLER_37_63 VPWR VGND sg13g2_decap_8
XFILLER_46_546 VPWR VGND sg13g2_decap_8
XFILLER_14_432 VPWR VGND sg13g2_decap_8
XFILLER_26_292 VPWR VGND sg13g2_decap_8
XFILLER_27_782 VPWR VGND sg13g2_fill_1
XFILLER_41_251 VPWR VGND sg13g2_decap_8
XFILLER_42_741 VPWR VGND sg13g2_fill_2
XFILLER_5_130 VPWR VGND sg13g2_decap_8
XFILLER_49_340 VPWR VGND sg13g2_decap_8
XFILLER_17_281 VPWR VGND sg13g2_decap_8
XFILLER_18_793 VPWR VGND sg13g2_fill_2
XFILLER_33_741 VPWR VGND sg13g2_fill_2
XFILLER_37_546 VPWR VGND sg13g2_decap_8
XFILLER_20_402 VPWR VGND sg13g2_decap_8
XFILLER_20_479 VPWR VGND sg13g2_decap_8
XFILLER_32_284 VPWR VGND sg13g2_decap_8
X_0967_ net100 VGND VPWR _0127_ daisychain\[63\] clknet_5_10__leaf_clk sg13g2_dfrbpq_1
XFILLER_9_480 VPWR VGND sg13g2_decap_8
XFILLER_0_818 VPWR VGND sg13g2_decap_4
X_0898_ VPWR _0016_ state\[56\] VGND sg13g2_inv_1
XFILLER_28_524 VPWR VGND sg13g2_decap_8
XFILLER_43_505 VPWR VGND sg13g2_decap_8
XFILLER_11_424 VPWR VGND sg13g2_decap_8
XFILLER_23_262 VPWR VGND sg13g2_decap_8
XFILLER_24_785 VPWR VGND sg13g2_fill_1
XFILLER_7_406 VPWR VGND sg13g2_decap_8
XFILLER_23_87 VPWR VGND sg13g2_decap_8
XFILLER_3_612 VPWR VGND sg13g2_fill_2
XFILLER_2_144 VPWR VGND sg13g2_decap_8
XFILLER_48_84 VPWR VGND sg13g2_decap_8
XFILLER_0_14 VPWR VGND sg13g2_decap_8
XFILLER_19_546 VPWR VGND sg13g2_decap_8
XFILLER_46_343 VPWR VGND sg13g2_decap_8
X_0821_ VPWR _0210_ daisychain\[17\] VGND sg13g2_inv_1
X_0752_ _0355_ VPWR _0160_ VGND net95 _0000_ sg13g2_o21ai_1
XFILLER_9_67 VPWR VGND sg13g2_decap_8
X_0683_ net92 VPWR _0423_ VGND net70 state\[55\] sg13g2_o21ai_1
XFILLER_6_494 VPWR VGND sg13g2_decap_8
XFILLER_37_343 VPWR VGND sg13g2_decap_8
XFILLER_21_722 VPWR VGND sg13g2_decap_8
XFILLER_33_571 VPWR VGND sg13g2_decap_8
XFILLER_40_519 VPWR VGND sg13g2_decap_8
XFILLER_20_276 VPWR VGND sg13g2_decap_8
XFILLER_18_76 VPWR VGND sg13g2_decap_8
XFILLER_28_321 VPWR VGND sg13g2_decap_8
XFILLER_28_398 VPWR VGND sg13g2_decap_8
XFILLER_43_346 VPWR VGND sg13g2_decap_8
XFILLER_11_221 VPWR VGND sg13g2_decap_8
XFILLER_11_298 VPWR VGND sg13g2_decap_8
XFILLER_24_560 VPWR VGND sg13g2_decap_8
XFILLER_31_519 VPWR VGND sg13g2_decap_8
XFILLER_34_53 VPWR VGND sg13g2_decap_8
XFILLER_8_737 VPWR VGND sg13g2_fill_1
XFILLER_7_203 VPWR VGND sg13g2_decap_8
XFILLER_3_431 VPWR VGND sg13g2_decap_8
XFILLER_19_343 VPWR VGND sg13g2_decap_8
XFILLER_22_8 VPWR VGND sg13g2_fill_1
XFILLER_46_140 VPWR VGND sg13g2_decap_8
XFILLER_47_674 VPWR VGND sg13g2_fill_2
X_1020_ net111 VGND VPWR _0180_ state\[52\] clknet_5_28__leaf_clk sg13g2_dfrbpq_1
Xclkbuf_4_11_0_clk clknet_0_clk clknet_4_11_0_clk VPWR VGND sg13g2_buf_8
XFILLER_34_368 VPWR VGND sg13g2_decap_8
XFILLER_30_552 VPWR VGND sg13g2_decap_8
X_0804_ VPWR _0063_ state\[9\] VGND sg13g2_inv_1
X_0735_ _0304_ VPWR _0143_ VGND net85 _0038_ sg13g2_o21ai_1
XFILLER_29_118 VPWR VGND sg13g2_decap_8
XFILLER_41_0 VPWR VGND sg13g2_decap_8
X_0666_ _0114_ _0409_ _0410_ net52 _0243_ VPWR VGND sg13g2_a22oi_1
X_0597_ VGND VPWR net28 daisychain\[32\] _0359_ net49 sg13g2_a21oi_1
XFILLER_6_291 VPWR VGND sg13g2_decap_8
XFILLER_25_335 VPWR VGND sg13g2_decap_8
XFILLER_37_140 VPWR VGND sg13g2_decap_8
XFILLER_21_563 VPWR VGND sg13g2_decap_8
XFILLER_40_349 VPWR VGND sg13g2_decap_8
XFILLER_20_66 VPWR VGND sg13g2_decap_8
XFILLER_5_718 VPWR VGND sg13g2_fill_1
XFILLER_0_434 VPWR VGND sg13g2_decap_8
XFILLER_29_663 VPWR VGND sg13g2_decap_8
XFILLER_29_97 VPWR VGND sg13g2_decap_8
XFILLER_48_427 VPWR VGND sg13g2_decap_8
XFILLER_16_368 VPWR VGND sg13g2_decap_8
XFILLER_28_195 VPWR VGND sg13g2_decap_8
XFILLER_31_316 VPWR VGND sg13g2_decap_8
XFILLER_43_143 VPWR VGND sg13g2_decap_8
XFILLER_44_633 VPWR VGND sg13g2_decap_8
XFILLER_44_655 VPWR VGND sg13g2_fill_2
XFILLER_44_699 VPWR VGND sg13g2_fill_2
XFILLER_45_85 VPWR VGND sg13g2_decap_8
XFILLER_12_585 VPWR VGND sg13g2_decap_8
XFILLER_8_545 VPWR VGND sg13g2_decap_8
XFILLER_6_46 VPWR VGND sg13g2_decap_8
X_0520_ _0207_ net64 _0300_ _0301_ VPWR VGND sg13g2_a21o_1
XFILLER_13_4 VPWR VGND sg13g2_fill_1
XFILLER_19_140 VPWR VGND sg13g2_decap_8
XFILLER_35_644 VPWR VGND sg13g2_fill_2
XFILLER_39_427 VPWR VGND sg13g2_decap_8
X_1003_ net111 VGND VPWR _0163_ state\[35\] clknet_5_25__leaf_clk sg13g2_dfrbpq_1
XFILLER_34_165 VPWR VGND sg13g2_decap_8
X_0718_ VGND VPWR net34 daisychain\[62\] _0450_ net35 sg13g2_a21oi_1
X_0649_ VGND VPWR net29 daisychain\[45\] _0398_ net50 sg13g2_a21oi_1
XFILLER_13_349 VPWR VGND sg13g2_decap_8
XFILLER_15_44 VPWR VGND sg13g2_decap_8
XFILLER_25_132 VPWR VGND sg13g2_decap_8
XFILLER_26_600 VPWR VGND sg13g2_decap_8
XFILLER_26_677 VPWR VGND sg13g2_decap_8
XFILLER_40_124 VPWR VGND sg13g2_decap_8
XFILLER_21_360 VPWR VGND sg13g2_decap_8
XFILLER_5_515 VPWR VGND sg13g2_decap_8
XFILLER_0_231 VPWR VGND sg13g2_decap_8
Xoutput8 net8 uio_out[0] VPWR VGND sg13g2_buf_1
Xoutput21 net21 uo_out[5] VPWR VGND sg13g2_buf_1
Xoutput10 net10 uio_out[2] VPWR VGND sg13g2_buf_1
XFILLER_29_482 VPWR VGND sg13g2_decap_8
XFILLER_48_224 VPWR VGND sg13g2_decap_8
XFILLER_16_165 VPWR VGND sg13g2_decap_8
XFILLER_31_113 VPWR VGND sg13g2_decap_8
XFILLER_32_669 VPWR VGND sg13g2_decap_8
XFILLER_8_342 VPWR VGND sg13g2_decap_8
XFILLER_39_224 VPWR VGND sg13g2_decap_8
X_0503_ net84 VPWR _0288_ VGND net63 state\[10\] sg13g2_o21ai_1
XFILLER_23_647 VPWR VGND sg13g2_decap_8
XFILLER_35_441 VPWR VGND sg13g2_decap_8
XFILLER_22_168 VPWR VGND sg13g2_decap_8
XFILLER_2_529 VPWR VGND sg13g2_decap_8
XFILLER_18_419 VPWR VGND sg13g2_decap_8
Xclkbuf_5_23__f_clk clknet_5_23__leaf_clk clknet_4_11_0_clk VPWR VGND sg13g2_buf_16
XFILLER_13_146 VPWR VGND sg13g2_decap_8
XFILLER_14_614 VPWR VGND sg13g2_decap_4
XFILLER_14_669 VPWR VGND sg13g2_decap_8
XFILLER_26_474 VPWR VGND sg13g2_decap_8
XFILLER_41_433 VPWR VGND sg13g2_decap_8
XFILLER_42_75 VPWR VGND sg13g2_decap_8
XFILLER_5_389 VPWR VGND sg13g2_decap_8
XFILLER_5_312 VPWR VGND sg13g2_decap_8
XFILLER_3_25 VPWR VGND sg13g2_decap_8
XFILLER_49_522 VPWR VGND sg13g2_decap_8
XFILLER_17_463 VPWR VGND sg13g2_decap_8
XFILLER_36_238 VPWR VGND sg13g2_decap_8
XFILLER_44_271 VPWR VGND sg13g2_decap_8
XFILLER_49_599 VPWR VGND sg13g2_decap_8
XFILLER_32_466 VPWR VGND sg13g2_decap_8
X_0983_ net110 VGND VPWR _0143_ state\[15\] clknet_5_7__leaf_clk sg13g2_dfrbpq_1
Xfanout107 net110 net107 VPWR VGND sg13g2_buf_1
Xfanout118 net119 net118 VPWR VGND sg13g2_buf_1
XFILLER_27_238 VPWR VGND sg13g2_decap_8
XFILLER_11_617 VPWR VGND sg13g2_fill_2
XFILLER_23_444 VPWR VGND sg13g2_decap_8
XFILLER_12_34 VPWR VGND sg13g2_decap_8
XFILLER_6_109 VPWR VGND sg13g2_decap_8
XFILLER_2_326 VPWR VGND sg13g2_decap_8
XFILLER_14_411 VPWR VGND sg13g2_decap_8
XFILLER_18_216 VPWR VGND sg13g2_decap_8
XFILLER_26_271 VPWR VGND sg13g2_decap_8
XFILLER_37_42 VPWR VGND sg13g2_decap_8
XFILLER_46_525 VPWR VGND sg13g2_decap_8
XFILLER_14_488 VPWR VGND sg13g2_decap_8
XFILLER_41_230 VPWR VGND sg13g2_decap_8
XFILLER_45_7 VPWR VGND sg13g2_decap_8
XFILLER_5_186 VPWR VGND sg13g2_decap_8
XFILLER_1_392 VPWR VGND sg13g2_decap_8
XFILLER_37_525 VPWR VGND sg13g2_decap_8
XFILLER_49_396 VPWR VGND sg13g2_decap_8
XFILLER_17_260 VPWR VGND sg13g2_decap_8
XFILLER_18_783 VPWR VGND sg13g2_decap_4
XFILLER_32_263 VPWR VGND sg13g2_decap_8
XFILLER_20_458 VPWR VGND sg13g2_decap_8
X_0897_ VPWR _0248_ daisychain\[55\] VGND sg13g2_inv_1
X_0966_ net100 VGND VPWR _0126_ daisychain\[62\] clknet_5_11__leaf_clk sg13g2_dfrbpq_1
XFILLER_4_90 VPWR VGND sg13g2_decap_8
XFILLER_15_219 VPWR VGND sg13g2_decap_8
XFILLER_28_503 VPWR VGND sg13g2_decap_8
XFILLER_11_403 VPWR VGND sg13g2_decap_8
XFILLER_23_11 VPWR VGND sg13g2_decap_4
XFILLER_23_241 VPWR VGND sg13g2_decap_8
XFILLER_23_33 VPWR VGND sg13g2_fill_1
XFILLER_23_66 VPWR VGND sg13g2_decap_8
XFILLER_2_123 VPWR VGND sg13g2_decap_8
XFILLER_19_525 VPWR VGND sg13g2_decap_8
XFILLER_46_322 VPWR VGND sg13g2_decap_8
XFILLER_48_63 VPWR VGND sg13g2_decap_8
XFILLER_42_572 VPWR VGND sg13g2_decap_8
XFILLER_46_399 VPWR VGND sg13g2_decap_8
XFILLER_14_285 VPWR VGND sg13g2_decap_8
X_0820_ VPWR _0040_ state\[17\] VGND sg13g2_inv_1
X_0751_ _0352_ VPWR _0159_ VGND net88 _0056_ sg13g2_o21ai_1
XFILLER_9_46 VPWR VGND sg13g2_decap_8
X_0682_ _0118_ _0421_ _0422_ net49 _0247_ VPWR VGND sg13g2_a22oi_1
XFILLER_6_473 VPWR VGND sg13g2_decap_8
XFILLER_18_580 VPWR VGND sg13g2_decap_8
XFILLER_37_322 VPWR VGND sg13g2_decap_8
XFILLER_37_399 VPWR VGND sg13g2_decap_8
XFILLER_49_193 VPWR VGND sg13g2_decap_8
XFILLER_20_255 VPWR VGND sg13g2_decap_8
XFILLER_21_778 VPWR VGND sg13g2_fill_1
XFILLER_33_550 VPWR VGND sg13g2_decap_8
X_0949_ net114 VGND VPWR _0109_ daisychain\[45\] clknet_5_21__leaf_clk sg13g2_dfrbpq_1
XFILLER_28_300 VPWR VGND sg13g2_decap_8
XFILLER_47_119 VPWR VGND sg13g2_decap_8
XFILLER_48_609 VPWR VGND sg13g2_decap_8
XFILLER_18_55 VPWR VGND sg13g2_decap_8
XFILLER_28_377 VPWR VGND sg13g2_decap_8
XFILLER_34_32 VPWR VGND sg13g2_decap_8
XFILLER_43_325 VPWR VGND sg13g2_decap_8
XFILLER_11_200 VPWR VGND sg13g2_decap_8
XFILLER_11_277 VPWR VGND sg13g2_decap_8
XFILLER_7_259 VPWR VGND sg13g2_decap_8
XFILLER_1_0 VPWR VGND sg13g2_decap_8
XFILLER_3_410 VPWR VGND sg13g2_decap_8
XFILLER_3_487 VPWR VGND sg13g2_decap_8
XFILLER_19_322 VPWR VGND sg13g2_decap_8
XFILLER_19_399 VPWR VGND sg13g2_decap_8
XFILLER_38_119 VPWR VGND sg13g2_decap_8
XFILLER_47_620 VPWR VGND sg13g2_fill_2
XFILLER_15_583 VPWR VGND sg13g2_decap_8
XFILLER_30_531 VPWR VGND sg13g2_decap_8
XFILLER_34_347 VPWR VGND sg13g2_decap_8
XFILLER_46_196 VPWR VGND sg13g2_decap_8
X_0803_ VPWR _0201_ daisychain\[8\] VGND sg13g2_inv_1
X_0734_ _0301_ VPWR _0142_ VGND net85 _0037_ sg13g2_o21ai_1
X_0665_ VGND VPWR net30 daisychain\[49\] _0410_ net52 sg13g2_a21oi_1
XFILLER_6_270 VPWR VGND sg13g2_decap_8
X_0596_ _0226_ net71 _0357_ _0358_ VPWR VGND sg13g2_a21o_1
XFILLER_1_91 VPWR VGND sg13g2_decap_8
XFILLER_25_314 VPWR VGND sg13g2_decap_8
XFILLER_37_196 VPWR VGND sg13g2_decap_8
Xclkbuf_5_4__f_clk clknet_5_4__leaf_clk clknet_4_2_0_clk VPWR VGND sg13g2_buf_16
XFILLER_21_542 VPWR VGND sg13g2_decap_8
XFILLER_40_328 VPWR VGND sg13g2_decap_8
XFILLER_0_413 VPWR VGND sg13g2_decap_8
XFILLER_20_45 VPWR VGND sg13g2_decap_8
XFILLER_28_174 VPWR VGND sg13g2_decap_8
XFILLER_29_642 VPWR VGND sg13g2_decap_8
XFILLER_29_76 VPWR VGND sg13g2_decap_8
XFILLER_48_406 VPWR VGND sg13g2_decap_8
XFILLER_12_564 VPWR VGND sg13g2_decap_8
XFILLER_16_347 VPWR VGND sg13g2_decap_8
XFILLER_43_122 VPWR VGND sg13g2_decap_8
XFILLER_43_199 VPWR VGND sg13g2_decap_8
XFILLER_45_64 VPWR VGND sg13g2_decap_8
XFILLER_8_524 VPWR VGND sg13g2_decap_8
XFILLER_6_25 VPWR VGND sg13g2_decap_8
XFILLER_39_406 VPWR VGND sg13g2_decap_8
XFILLER_3_284 VPWR VGND sg13g2_decap_8
XFILLER_19_196 VPWR VGND sg13g2_decap_8
XFILLER_34_144 VPWR VGND sg13g2_decap_8
XFILLER_35_623 VPWR VGND sg13g2_decap_8
XFILLER_47_483 VPWR VGND sg13g2_decap_8
X_1002_ net111 VGND VPWR _0162_ state\[34\] clknet_5_16__leaf_clk sg13g2_dfrbpq_1
XFILLER_15_380 VPWR VGND sg13g2_decap_8
X_0717_ _0256_ net57 _0448_ _0449_ VPWR VGND sg13g2_a21o_1
X_0648_ _0239_ net73 _0396_ _0397_ VPWR VGND sg13g2_a21o_1
XFILLER_38_483 VPWR VGND sg13g2_decap_8
X_0579_ net83 VPWR _0345_ VGND net62 state\[29\] sg13g2_o21ai_1
XFILLER_13_328 VPWR VGND sg13g2_decap_8
XFILLER_14_818 VPWR VGND sg13g2_decap_4
XFILLER_25_111 VPWR VGND sg13g2_decap_8
XFILLER_25_188 VPWR VGND sg13g2_decap_8
XFILLER_26_656 VPWR VGND sg13g2_decap_8
XFILLER_40_103 VPWR VGND sg13g2_decap_8
XFILLER_41_659 VPWR VGND sg13g2_decap_4
XFILLER_31_99 VPWR VGND sg13g2_decap_8
Xclkbuf_4_10_0_clk clknet_0_clk clknet_4_10_0_clk VPWR VGND sg13g2_buf_8
XFILLER_0_210 VPWR VGND sg13g2_decap_8
XFILLER_0_287 VPWR VGND sg13g2_decap_8
XFILLER_48_203 VPWR VGND sg13g2_decap_8
Xoutput9 net9 uio_out[1] VPWR VGND sg13g2_buf_1
Xoutput22 net22 uo_out[6] VPWR VGND sg13g2_buf_1
Xoutput11 net11 uio_out[3] VPWR VGND sg13g2_buf_1
XFILLER_16_144 VPWR VGND sg13g2_decap_8
XFILLER_17_645 VPWR VGND sg13g2_decap_8
XFILLER_29_461 VPWR VGND sg13g2_decap_8
XFILLER_44_453 VPWR VGND sg13g2_fill_2
XFILLER_31_169 VPWR VGND sg13g2_decap_8
XFILLER_32_648 VPWR VGND sg13g2_decap_8
XFILLER_8_321 VPWR VGND sg13g2_decap_8
X_0502_ _0073_ _0286_ _0287_ net41 _0202_ VPWR VGND sg13g2_a22oi_1
XFILLER_8_398 VPWR VGND sg13g2_decap_8
XFILLER_39_203 VPWR VGND sg13g2_decap_8
XFILLER_22_147 VPWR VGND sg13g2_decap_8
XFILLER_23_626 VPWR VGND sg13g2_decap_8
XFILLER_35_420 VPWR VGND sg13g2_decap_8
XFILLER_35_497 VPWR VGND sg13g2_decap_8
XFILLER_47_280 VPWR VGND sg13g2_decap_8
XFILLER_2_508 VPWR VGND sg13g2_decap_8
XFILLER_26_11 VPWR VGND sg13g2_decap_4
XFILLER_26_453 VPWR VGND sg13g2_decap_8
XFILLER_38_280 VPWR VGND sg13g2_decap_8
XFILLER_45_239 VPWR VGND sg13g2_decap_8
XFILLER_13_125 VPWR VGND sg13g2_decap_8
XFILLER_41_412 VPWR VGND sg13g2_decap_8
XFILLER_41_489 VPWR VGND sg13g2_decap_8
XFILLER_42_21 VPWR VGND sg13g2_decap_8
XFILLER_42_54 VPWR VGND sg13g2_decap_8
XFILLER_5_368 VPWR VGND sg13g2_decap_8
XFILLER_36_217 VPWR VGND sg13g2_decap_8
XFILLER_49_578 VPWR VGND sg13g2_decap_8
XFILLER_49_501 VPWR VGND sg13g2_decap_8
XFILLER_17_442 VPWR VGND sg13g2_decap_8
XFILLER_32_445 VPWR VGND sg13g2_decap_8
XFILLER_44_250 VPWR VGND sg13g2_decap_8
X_0982_ net110 VGND VPWR _0142_ state\[14\] clknet_5_5__leaf_clk sg13g2_dfrbpq_1
XFILLER_8_195 VPWR VGND sg13g2_decap_8
Xfanout108 net109 net108 VPWR VGND sg13g2_buf_1
Xfanout119 net1 net119 VPWR VGND sg13g2_buf_1
XFILLER_27_217 VPWR VGND sg13g2_decap_8
XFILLER_10_139 VPWR VGND sg13g2_decap_8
XFILLER_23_423 VPWR VGND sg13g2_decap_8
XFILLER_35_294 VPWR VGND sg13g2_decap_8
XFILLER_12_13 VPWR VGND sg13g2_decap_8
XFILLER_2_305 VPWR VGND sg13g2_decap_8
XFILLER_19_718 VPWR VGND sg13g2_fill_1
XFILLER_37_21 VPWR VGND sg13g2_decap_8
XFILLER_46_504 VPWR VGND sg13g2_decap_8
XFILLER_26_250 VPWR VGND sg13g2_decap_8
XFILLER_27_773 VPWR VGND sg13g2_decap_8
XFILLER_37_98 VPWR VGND sg13g2_decap_8
XFILLER_42_743 VPWR VGND sg13g2_fill_1
XFILLER_14_467 VPWR VGND sg13g2_decap_8
XFILLER_41_286 VPWR VGND sg13g2_decap_8
XFILLER_1_371 VPWR VGND sg13g2_decap_8
XFILLER_38_7 VPWR VGND sg13g2_decap_8
XFILLER_6_699 VPWR VGND sg13g2_fill_2
XFILLER_5_165 VPWR VGND sg13g2_decap_8
XFILLER_37_504 VPWR VGND sg13g2_decap_8
XFILLER_49_375 VPWR VGND sg13g2_decap_8
XFILLER_20_437 VPWR VGND sg13g2_decap_8
XFILLER_32_242 VPWR VGND sg13g2_decap_8
X_0896_ VPWR _0015_ state\[55\] VGND sg13g2_inv_1
X_0965_ net100 VGND VPWR _0125_ daisychain\[61\] clknet_5_10__leaf_clk sg13g2_dfrbpq_1
XFILLER_23_220 VPWR VGND sg13g2_decap_8
XFILLER_28_559 VPWR VGND sg13g2_decap_8
XFILLER_36_581 VPWR VGND sg13g2_decap_8
XFILLER_11_459 VPWR VGND sg13g2_decap_8
XFILLER_23_297 VPWR VGND sg13g2_decap_8
XFILLER_2_102 VPWR VGND sg13g2_decap_8
XFILLER_2_179 VPWR VGND sg13g2_decap_8
XFILLER_3_4 VPWR VGND sg13g2_decap_8
XFILLER_0_49 VPWR VGND sg13g2_decap_8
XFILLER_19_504 VPWR VGND sg13g2_decap_8
XFILLER_46_301 VPWR VGND sg13g2_decap_8
XFILLER_48_42 VPWR VGND sg13g2_decap_8
XFILLER_14_264 VPWR VGND sg13g2_decap_8
XFILLER_15_754 VPWR VGND sg13g2_decap_8
XFILLER_27_581 VPWR VGND sg13g2_decap_8
XFILLER_30_713 VPWR VGND sg13g2_decap_8
XFILLER_34_529 VPWR VGND sg13g2_decap_8
XFILLER_42_551 VPWR VGND sg13g2_decap_8
XFILLER_46_378 VPWR VGND sg13g2_decap_8
XFILLER_9_25 VPWR VGND sg13g2_decap_8
Xfanout90 net93 net90 VPWR VGND sg13g2_buf_1
X_0750_ _0349_ VPWR _0158_ VGND net89 _0055_ sg13g2_o21ai_1
X_0681_ VGND VPWR net31 daisychain\[53\] _0422_ net48 sg13g2_a21oi_1
XFILLER_6_452 VPWR VGND sg13g2_decap_8
XFILLER_25_529 VPWR VGND sg13g2_decap_8
XFILLER_37_301 VPWR VGND sg13g2_decap_8
XFILLER_37_378 VPWR VGND sg13g2_decap_8
XFILLER_49_172 VPWR VGND sg13g2_decap_8
XFILLER_20_234 VPWR VGND sg13g2_decap_8
XFILLER_21_713 VPWR VGND sg13g2_fill_2
X_0948_ net114 VGND VPWR _0108_ daisychain\[44\] clknet_5_21__leaf_clk sg13g2_dfrbpq_1
X_0879_ VPWR _0239_ daisychain\[46\] VGND sg13g2_inv_1
XFILLER_0_639 VPWR VGND sg13g2_decap_4
XFILLER_18_34 VPWR VGND sg13g2_decap_8
XFILLER_28_356 VPWR VGND sg13g2_decap_8
XFILLER_16_529 VPWR VGND sg13g2_decap_8
XFILLER_24_595 VPWR VGND sg13g2_decap_8
XFILLER_34_11 VPWR VGND sg13g2_decap_8
XFILLER_34_88 VPWR VGND sg13g2_decap_8
XFILLER_43_304 VPWR VGND sg13g2_decap_8
XFILLER_11_256 VPWR VGND sg13g2_decap_8
XFILLER_20_790 VPWR VGND sg13g2_decap_8
XFILLER_7_238 VPWR VGND sg13g2_decap_8
XFILLER_3_466 VPWR VGND sg13g2_decap_8
XFILLER_19_301 VPWR VGND sg13g2_decap_8
XFILLER_19_378 VPWR VGND sg13g2_decap_8
XFILLER_34_326 VPWR VGND sg13g2_decap_8
XFILLER_46_175 VPWR VGND sg13g2_decap_8
XFILLER_15_562 VPWR VGND sg13g2_decap_8
XFILLER_30_510 VPWR VGND sg13g2_decap_8
XFILLER_30_587 VPWR VGND sg13g2_decap_8
XFILLER_42_392 VPWR VGND sg13g2_decap_8
X_0802_ VPWR _0062_ state\[8\] VGND sg13g2_inv_1
X_0733_ _0298_ VPWR _0141_ VGND net84 _0036_ sg13g2_o21ai_1
X_0664_ _0243_ net74 _0408_ _0409_ VPWR VGND sg13g2_a21o_1
XFILLER_27_0 VPWR VGND sg13g2_decap_8
X_0595_ net93 VPWR _0357_ VGND net71 state\[33\] sg13g2_o21ai_1
XFILLER_1_70 VPWR VGND sg13g2_decap_8
XFILLER_21_521 VPWR VGND sg13g2_decap_8
XFILLER_37_175 VPWR VGND sg13g2_decap_8
XFILLER_38_698 VPWR VGND sg13g2_fill_2
XFILLER_40_307 VPWR VGND sg13g2_decap_8
XFILLER_20_13 VPWR VGND sg13g2_decap_8
XFILLER_20_24 VPWR VGND sg13g2_decap_8
XFILLER_21_598 VPWR VGND sg13g2_decap_8
XFILLER_0_469 VPWR VGND sg13g2_decap_8
XFILLER_16_326 VPWR VGND sg13g2_decap_8
XFILLER_28_153 VPWR VGND sg13g2_decap_8
XFILLER_29_55 VPWR VGND sg13g2_decap_8
XFILLER_29_621 VPWR VGND sg13g2_decap_8
XFILLER_29_698 VPWR VGND sg13g2_decap_8
XFILLER_43_101 VPWR VGND sg13g2_decap_8
XFILLER_44_657 VPWR VGND sg13g2_fill_1
XFILLER_45_21 VPWR VGND sg13g2_decap_8
XFILLER_45_43 VPWR VGND sg13g2_decap_8
XFILLER_12_543 VPWR VGND sg13g2_decap_8
XFILLER_24_392 VPWR VGND sg13g2_decap_8
XFILLER_43_178 VPWR VGND sg13g2_decap_8
XFILLER_8_503 VPWR VGND sg13g2_decap_8
XFILLER_3_263 VPWR VGND sg13g2_decap_8
XFILLER_10_90 VPWR VGND sg13g2_decap_8
XFILLER_19_175 VPWR VGND sg13g2_decap_8
XFILLER_22_329 VPWR VGND sg13g2_decap_8
XFILLER_34_123 VPWR VGND sg13g2_decap_8
XFILLER_35_602 VPWR VGND sg13g2_decap_8
XFILLER_35_646 VPWR VGND sg13g2_fill_1
XFILLER_47_462 VPWR VGND sg13g2_decap_8
X_1001_ net113 VGND VPWR _0161_ state\[33\] clknet_5_16__leaf_clk sg13g2_dfrbpq_1
XFILLER_30_384 VPWR VGND sg13g2_decap_8
X_0716_ net80 VPWR _0448_ VGND net57 state\[63\] sg13g2_o21ai_1
X_0647_ net94 VPWR _0396_ VGND net76 state\[46\] sg13g2_o21ai_1
X_0578_ _0092_ _0343_ _0344_ net40 _0221_ VPWR VGND sg13g2_a22oi_1
XFILLER_26_635 VPWR VGND sg13g2_decap_8
XFILLER_38_462 VPWR VGND sg13g2_decap_8
XFILLER_13_307 VPWR VGND sg13g2_decap_8
XFILLER_15_79 VPWR VGND sg13g2_decap_8
XFILLER_25_167 VPWR VGND sg13g2_decap_8
XFILLER_21_395 VPWR VGND sg13g2_decap_8
XFILLER_31_78 VPWR VGND sg13g2_decap_8
Xoutput23 net23 uo_out[7] VPWR VGND sg13g2_buf_1
Xoutput12 net12 uio_out[4] VPWR VGND sg13g2_buf_1
XFILLER_0_266 VPWR VGND sg13g2_decap_8
XFILLER_29_440 VPWR VGND sg13g2_decap_8
XFILLER_49_738 VPWR VGND sg13g2_fill_1
XFILLER_49_727 VPWR VGND sg13g2_fill_2
XFILLER_48_259 VPWR VGND sg13g2_decap_8
XFILLER_16_123 VPWR VGND sg13g2_decap_8
XFILLER_17_624 VPWR VGND sg13g2_decap_8
XFILLER_32_627 VPWR VGND sg13g2_decap_8
XFILLER_44_432 VPWR VGND sg13g2_decap_8
XFILLER_44_487 VPWR VGND sg13g2_decap_8
XFILLER_12_384 VPWR VGND sg13g2_fill_1
XFILLER_25_690 VPWR VGND sg13g2_decap_8
XFILLER_31_148 VPWR VGND sg13g2_decap_8
XFILLER_8_377 VPWR VGND sg13g2_decap_8
XFILLER_8_300 VPWR VGND sg13g2_decap_8
X_0501_ VGND VPWR net24 daisychain\[8\] _0287_ net38 sg13g2_a21oi_1
XFILLER_4_572 VPWR VGND sg13g2_fill_2
XFILLER_39_259 VPWR VGND sg13g2_decap_8
XFILLER_22_126 VPWR VGND sg13g2_decap_8
XFILLER_23_605 VPWR VGND sg13g2_decap_8
XFILLER_31_671 VPWR VGND sg13g2_decap_8
XFILLER_35_476 VPWR VGND sg13g2_decap_8
XFILLER_30_181 VPWR VGND sg13g2_decap_8
XFILLER_7_91 VPWR VGND sg13g2_decap_8
XFILLER_13_104 VPWR VGND sg13g2_decap_8
XFILLER_26_432 VPWR VGND sg13g2_decap_8
XFILLER_26_89 VPWR VGND sg13g2_decap_8
XFILLER_45_218 VPWR VGND sg13g2_decap_8
XFILLER_21_192 VPWR VGND sg13g2_decap_8
XFILLER_22_693 VPWR VGND sg13g2_fill_1
XFILLER_41_468 VPWR VGND sg13g2_decap_8
XFILLER_42_33 VPWR VGND sg13g2_decap_8
XFILLER_1_553 VPWR VGND sg13g2_decap_8
XFILLER_5_347 VPWR VGND sg13g2_decap_8
XFILLER_17_421 VPWR VGND sg13g2_decap_8
XFILLER_37_708 VPWR VGND sg13g2_decap_4
XFILLER_49_557 VPWR VGND sg13g2_decap_8
XFILLER_17_498 VPWR VGND sg13g2_decap_8
XFILLER_20_619 VPWR VGND sg13g2_decap_8
XFILLER_32_424 VPWR VGND sg13g2_decap_8
X_0981_ net107 VGND VPWR _0141_ state\[13\] clknet_5_7__leaf_clk sg13g2_dfrbpq_1
XFILLER_12_181 VPWR VGND sg13g2_decap_8
XFILLER_9_653 VPWR VGND sg13g2_decap_8
XFILLER_9_642 VPWR VGND sg13g2_decap_4
XFILLER_8_174 VPWR VGND sg13g2_decap_8
Xfanout109 net110 net109 VPWR VGND sg13g2_buf_1
XFILLER_4_391 VPWR VGND sg13g2_decap_8
XFILLER_23_402 VPWR VGND sg13g2_decap_8
XFILLER_28_719 VPWR VGND sg13g2_decap_8
XFILLER_35_273 VPWR VGND sg13g2_decap_8
XFILLER_10_118 VPWR VGND sg13g2_decap_8
XFILLER_11_608 VPWR VGND sg13g2_fill_1
XFILLER_23_479 VPWR VGND sg13g2_decap_8
XFILLER_12_69 VPWR VGND sg13g2_decap_8
XFILLER_14_446 VPWR VGND sg13g2_decap_8
XFILLER_27_796 VPWR VGND sg13g2_fill_2
XFILLER_37_77 VPWR VGND sg13g2_decap_8
XFILLER_41_265 VPWR VGND sg13g2_decap_8
XFILLER_22_490 VPWR VGND sg13g2_decap_8
XFILLER_5_144 VPWR VGND sg13g2_decap_8
XFILLER_1_350 VPWR VGND sg13g2_decap_8
XFILLER_45_582 VPWR VGND sg13g2_decap_8
XFILLER_49_354 VPWR VGND sg13g2_decap_8
XFILLER_17_295 VPWR VGND sg13g2_decap_8
XFILLER_20_416 VPWR VGND sg13g2_decap_8
XFILLER_32_221 VPWR VGND sg13g2_decap_8
XFILLER_32_298 VPWR VGND sg13g2_decap_8
XFILLER_33_777 VPWR VGND sg13g2_decap_4
XFILLER_33_799 VPWR VGND sg13g2_decap_8
X_0964_ net100 VGND VPWR _0124_ daisychain\[60\] clknet_5_10__leaf_clk sg13g2_dfrbpq_1
X_0895_ VPWR _0247_ daisychain\[54\] VGND sg13g2_inv_1
XFILLER_9_494 VPWR VGND sg13g2_decap_8
XFILLER_28_538 VPWR VGND sg13g2_decap_8
XFILLER_24_700 VPWR VGND sg13g2_decap_8
XFILLER_24_722 VPWR VGND sg13g2_decap_8
XFILLER_24_744 VPWR VGND sg13g2_decap_8
XFILLER_24_755 VPWR VGND sg13g2_fill_2
XFILLER_36_560 VPWR VGND sg13g2_decap_8
XFILLER_43_519 VPWR VGND sg13g2_decap_8
XFILLER_11_438 VPWR VGND sg13g2_fill_1
XFILLER_23_24 VPWR VGND sg13g2_decap_8
XFILLER_23_276 VPWR VGND sg13g2_decap_8
XFILLER_2_158 VPWR VGND sg13g2_decap_8
XFILLER_48_21 VPWR VGND sg13g2_decap_8
XFILLER_0_28 VPWR VGND sg13g2_decap_8
XFILLER_27_560 VPWR VGND sg13g2_decap_8
XFILLER_34_508 VPWR VGND sg13g2_decap_8
XFILLER_46_357 VPWR VGND sg13g2_decap_8
XFILLER_48_98 VPWR VGND sg13g2_decap_8
XFILLER_14_243 VPWR VGND sg13g2_decap_8
XFILLER_15_799 VPWR VGND sg13g2_fill_1
XFILLER_42_530 VPWR VGND sg13g2_decap_8
Xfanout91 net92 net91 VPWR VGND sg13g2_buf_1
Xfanout80 net4 net80 VPWR VGND sg13g2_buf_1
XFILLER_10_482 VPWR VGND sg13g2_decap_8
XFILLER_13_90 VPWR VGND sg13g2_decap_8
X_0680_ _0247_ net71 _0420_ _0421_ VPWR VGND sg13g2_a21o_1
XFILLER_6_431 VPWR VGND sg13g2_decap_8
XFILLER_29_4 VPWR VGND sg13g2_fill_2
XFILLER_49_151 VPWR VGND sg13g2_decap_8
XFILLER_21_703 VPWR VGND sg13g2_decap_4
XFILLER_25_508 VPWR VGND sg13g2_decap_8
XFILLER_37_357 VPWR VGND sg13g2_decap_8
XFILLER_20_213 VPWR VGND sg13g2_decap_8
XFILLER_21_736 VPWR VGND sg13g2_decap_4
XFILLER_21_769 VPWR VGND sg13g2_decap_8
XFILLER_33_585 VPWR VGND sg13g2_decap_8
X_0947_ net114 VGND VPWR _0107_ daisychain\[43\] clknet_5_21__leaf_clk sg13g2_dfrbpq_1
XFILLER_9_291 VPWR VGND sg13g2_decap_8
XFILLER_0_607 VPWR VGND sg13g2_fill_2
X_0878_ VPWR _0005_ state\[46\] VGND sg13g2_inv_1
XFILLER_16_508 VPWR VGND sg13g2_decap_8
XFILLER_28_335 VPWR VGND sg13g2_decap_8
XFILLER_11_235 VPWR VGND sg13g2_decap_8
XFILLER_24_574 VPWR VGND sg13g2_decap_8
XFILLER_34_67 VPWR VGND sg13g2_decap_8
XFILLER_3_445 VPWR VGND sg13g2_decap_8
XFILLER_7_217 VPWR VGND sg13g2_decap_8
Xclkbuf_5_29__f_clk clknet_5_29__leaf_clk clknet_4_14_0_clk VPWR VGND sg13g2_buf_16
XFILLER_15_541 VPWR VGND sg13g2_decap_8
XFILLER_19_357 VPWR VGND sg13g2_decap_8
XFILLER_34_305 VPWR VGND sg13g2_decap_8
XFILLER_46_154 VPWR VGND sg13g2_decap_8
XFILLER_47_655 VPWR VGND sg13g2_fill_1
XFILLER_30_566 VPWR VGND sg13g2_decap_8
XFILLER_42_371 VPWR VGND sg13g2_decap_8
X_0801_ VPWR _0200_ daisychain\[7\] VGND sg13g2_inv_1
X_0732_ _0295_ VPWR _0140_ VGND net84 _0035_ sg13g2_o21ai_1
X_0663_ net96 VPWR _0408_ VGND net74 state\[50\] sg13g2_o21ai_1
X_0594_ _0096_ _0355_ _0356_ net51 _0225_ VPWR VGND sg13g2_a22oi_1
XFILLER_37_154 VPWR VGND sg13g2_decap_8
XFILLER_21_500 VPWR VGND sg13g2_decap_8
XFILLER_25_349 VPWR VGND sg13g2_decap_8
XFILLER_33_382 VPWR VGND sg13g2_decap_8
XFILLER_21_577 VPWR VGND sg13g2_decap_8
XFILLER_4_209 VPWR VGND sg13g2_decap_8
XFILLER_0_448 VPWR VGND sg13g2_decap_8
XFILLER_29_34 VPWR VGND sg13g2_decap_8
XFILLER_16_305 VPWR VGND sg13g2_decap_8
XFILLER_17_806 VPWR VGND sg13g2_decap_8
XFILLER_28_132 VPWR VGND sg13g2_decap_8
XFILLER_29_677 VPWR VGND sg13g2_decap_8
XFILLER_43_157 VPWR VGND sg13g2_decap_8
XFILLER_44_647 VPWR VGND sg13g2_decap_4
XFILLER_45_99 VPWR VGND sg13g2_decap_8
XFILLER_12_522 VPWR VGND sg13g2_decap_8
XFILLER_12_599 VPWR VGND sg13g2_decap_8
XFILLER_24_371 VPWR VGND sg13g2_decap_8
XFILLER_8_559 VPWR VGND sg13g2_decap_8
XFILLER_3_242 VPWR VGND sg13g2_decap_8
XFILLER_4_710 VPWR VGND sg13g2_fill_1
XFILLER_19_154 VPWR VGND sg13g2_decap_8
XFILLER_20_8 VPWR VGND sg13g2_fill_1
XFILLER_47_441 VPWR VGND sg13g2_decap_8
X_1000_ net115 VGND VPWR _0160_ state\[32\] clknet_5_19__leaf_clk sg13g2_dfrbpq_1
XFILLER_22_308 VPWR VGND sg13g2_decap_8
XFILLER_34_102 VPWR VGND sg13g2_decap_8
XFILLER_34_179 VPWR VGND sg13g2_decap_8
XFILLER_30_363 VPWR VGND sg13g2_decap_8
X_0715_ _0126_ _0446_ _0447_ net35 _0255_ VPWR VGND sg13g2_a22oi_1
Xclkbuf_5_12__f_clk clknet_5_12__leaf_clk clknet_4_6_0_clk VPWR VGND sg13g2_buf_16
X_0646_ _0109_ _0394_ _0395_ net50 _0238_ VPWR VGND sg13g2_a22oi_1
X_0577_ VGND VPWR net25 daisychain\[27\] _0344_ net40 sg13g2_a21oi_1
XFILLER_25_146 VPWR VGND sg13g2_decap_8
XFILLER_26_614 VPWR VGND sg13g2_decap_8
XFILLER_38_441 VPWR VGND sg13g2_decap_8
XFILLER_15_58 VPWR VGND sg13g2_decap_8
XFILLER_21_374 VPWR VGND sg13g2_decap_8
XFILLER_22_820 VPWR VGND sg13g2_fill_2
XFILLER_40_138 VPWR VGND sg13g2_decap_8
XFILLER_41_628 VPWR VGND sg13g2_decap_8
XFILLER_31_57 VPWR VGND sg13g2_decap_8
Xoutput13 net13 uio_out[5] VPWR VGND sg13g2_buf_1
XFILLER_5_529 VPWR VGND sg13g2_decap_8
XFILLER_0_245 VPWR VGND sg13g2_decap_8
XFILLER_17_603 VPWR VGND sg13g2_decap_8
XFILLER_49_717 VPWR VGND sg13g2_fill_1
XFILLER_48_238 VPWR VGND sg13g2_decap_8
XFILLER_16_102 VPWR VGND sg13g2_decap_8
XFILLER_16_179 VPWR VGND sg13g2_decap_8
XFILLER_29_496 VPWR VGND sg13g2_decap_4
XFILLER_31_127 VPWR VGND sg13g2_decap_8
XFILLER_32_606 VPWR VGND sg13g2_decap_8
XFILLER_44_411 VPWR VGND sg13g2_decap_8
XFILLER_44_466 VPWR VGND sg13g2_decap_8
XFILLER_12_363 VPWR VGND sg13g2_decap_8
XFILLER_8_356 VPWR VGND sg13g2_decap_8
X_0500_ _0202_ net63 _0285_ _0286_ VPWR VGND sg13g2_a21o_1
XFILLER_11_4 VPWR VGND sg13g2_decap_8
XFILLER_35_455 VPWR VGND sg13g2_decap_8
XFILLER_39_238 VPWR VGND sg13g2_decap_8
XFILLER_22_105 VPWR VGND sg13g2_decap_8
XFILLER_30_160 VPWR VGND sg13g2_decap_8
XFILLER_7_70 VPWR VGND sg13g2_decap_8
X_0629_ VGND VPWR net29 daisychain\[40\] _0383_ net51 sg13g2_a21oi_1
XFILLER_26_411 VPWR VGND sg13g2_decap_8
XFILLER_26_488 VPWR VGND sg13g2_decap_8
XFILLER_26_68 VPWR VGND sg13g2_decap_8
XFILLER_41_447 VPWR VGND sg13g2_decap_8
XFILLER_21_171 VPWR VGND sg13g2_decap_8
XFILLER_22_672 VPWR VGND sg13g2_decap_8
XFILLER_42_89 VPWR VGND sg13g2_decap_8
XFILLER_9_109 VPWR VGND sg13g2_decap_8
XFILLER_5_326 VPWR VGND sg13g2_decap_8
XFILLER_1_532 VPWR VGND sg13g2_decap_8
XFILLER_1_576 VPWR VGND sg13g2_decap_8
XFILLER_3_39 VPWR VGND sg13g2_decap_8
XFILLER_17_400 VPWR VGND sg13g2_decap_8
XFILLER_29_293 VPWR VGND sg13g2_decap_8
XFILLER_49_536 VPWR VGND sg13g2_decap_8
XFILLER_12_160 VPWR VGND sg13g2_decap_8
XFILLER_17_477 VPWR VGND sg13g2_decap_8
XFILLER_32_403 VPWR VGND sg13g2_decap_8
XFILLER_44_285 VPWR VGND sg13g2_decap_8
X_0980_ net107 VGND VPWR _0140_ state\[12\] clknet_5_7__leaf_clk sg13g2_dfrbpq_1
XFILLER_40_491 VPWR VGND sg13g2_decap_8
XFILLER_8_153 VPWR VGND sg13g2_decap_8
XFILLER_4_370 VPWR VGND sg13g2_decap_8
XFILLER_35_252 VPWR VGND sg13g2_decap_8
XFILLER_36_797 VPWR VGND sg13g2_decap_8
XFILLER_12_48 VPWR VGND sg13g2_decap_8
XFILLER_23_458 VPWR VGND sg13g2_decap_8
XFILLER_31_491 VPWR VGND sg13g2_decap_8
XFILLER_37_56 VPWR VGND sg13g2_decap_8
XFILLER_46_539 VPWR VGND sg13g2_decap_8
XFILLER_14_425 VPWR VGND sg13g2_decap_8
XFILLER_26_285 VPWR VGND sg13g2_decap_8
XFILLER_41_244 VPWR VGND sg13g2_decap_8
XFILLER_42_734 VPWR VGND sg13g2_decap_8
XFILLER_10_697 VPWR VGND sg13g2_fill_2
XFILLER_5_123 VPWR VGND sg13g2_decap_8
XFILLER_49_333 VPWR VGND sg13g2_decap_8
XFILLER_17_274 VPWR VGND sg13g2_decap_8
XFILLER_18_742 VPWR VGND sg13g2_fill_2
XFILLER_32_200 VPWR VGND sg13g2_decap_8
XFILLER_37_539 VPWR VGND sg13g2_decap_8
XFILLER_45_561 VPWR VGND sg13g2_decap_8
XFILLER_32_277 VPWR VGND sg13g2_decap_8
X_0894_ VPWR _0014_ state\[54\] VGND sg13g2_inv_1
X_0963_ net101 VGND VPWR _0123_ daisychain\[59\] clknet_5_18__leaf_clk sg13g2_dfrbpq_1
XFILLER_9_473 VPWR VGND sg13g2_decap_8
XFILLER_28_517 VPWR VGND sg13g2_decap_8
XFILLER_11_417 VPWR VGND sg13g2_decap_8
XFILLER_23_255 VPWR VGND sg13g2_decap_8
XFILLER_2_137 VPWR VGND sg13g2_decap_8
XFILLER_14_222 VPWR VGND sg13g2_decap_8
XFILLER_19_539 VPWR VGND sg13g2_decap_8
XFILLER_46_336 VPWR VGND sg13g2_decap_8
XFILLER_48_77 VPWR VGND sg13g2_decap_8
XFILLER_10_461 VPWR VGND sg13g2_decap_8
XFILLER_14_299 VPWR VGND sg13g2_decap_8
XFILLER_15_789 VPWR VGND sg13g2_decap_4
XFILLER_42_586 VPWR VGND sg13g2_decap_8
Xfanout92 net93 net92 VPWR VGND sg13g2_buf_1
Xfanout81 net82 net81 VPWR VGND sg13g2_buf_1
Xfanout70 net71 net70 VPWR VGND sg13g2_buf_1
XFILLER_6_410 VPWR VGND sg13g2_decap_8
XFILLER_43_7 VPWR VGND sg13g2_decap_8
XFILLER_6_487 VPWR VGND sg13g2_decap_8
XFILLER_2_693 VPWR VGND sg13g2_fill_2
XFILLER_37_336 VPWR VGND sg13g2_decap_8
XFILLER_49_130 VPWR VGND sg13g2_decap_8
XFILLER_18_594 VPWR VGND sg13g2_decap_8
XFILLER_33_564 VPWR VGND sg13g2_decap_8
XFILLER_20_269 VPWR VGND sg13g2_decap_8
X_0877_ VPWR _0238_ daisychain\[45\] VGND sg13g2_inv_1
X_0946_ net115 VGND VPWR _0106_ daisychain\[42\] clknet_5_17__leaf_clk sg13g2_dfrbpq_1
XFILLER_9_270 VPWR VGND sg13g2_decap_8
XFILLER_18_69 VPWR VGND sg13g2_decap_8
XFILLER_28_314 VPWR VGND sg13g2_decap_8
XFILLER_43_339 VPWR VGND sg13g2_decap_8
XFILLER_11_214 VPWR VGND sg13g2_decap_8
XFILLER_24_553 VPWR VGND sg13g2_decap_8
XFILLER_34_46 VPWR VGND sg13g2_decap_8
XFILLER_3_424 VPWR VGND sg13g2_decap_8
XFILLER_19_336 VPWR VGND sg13g2_decap_8
XFILLER_46_133 VPWR VGND sg13g2_decap_8
XFILLER_15_520 VPWR VGND sg13g2_decap_8
XFILLER_15_597 VPWR VGND sg13g2_decap_8
XFILLER_42_350 VPWR VGND sg13g2_decap_8
XFILLER_30_545 VPWR VGND sg13g2_decap_8
X_0800_ VPWR _0061_ state\[7\] VGND sg13g2_inv_1
X_0731_ _0292_ VPWR _0139_ VGND net83 _0034_ sg13g2_o21ai_1
X_0662_ _0113_ _0406_ _0407_ net53 _0242_ VPWR VGND sg13g2_a22oi_1
X_0593_ VGND VPWR net26 daisychain\[31\] _0356_ net45 sg13g2_a21oi_1
XFILLER_6_284 VPWR VGND sg13g2_decap_8
XFILLER_25_328 VPWR VGND sg13g2_decap_8
XFILLER_37_133 VPWR VGND sg13g2_decap_8
XFILLER_38_623 VPWR VGND sg13g2_decap_4
XFILLER_38_634 VPWR VGND sg13g2_fill_1
XFILLER_18_391 VPWR VGND sg13g2_decap_8
XFILLER_21_556 VPWR VGND sg13g2_decap_8
XFILLER_33_361 VPWR VGND sg13g2_decap_8
XFILLER_20_59 VPWR VGND sg13g2_decap_8
X_0929_ net105 VGND VPWR _0089_ daisychain\[25\] clknet_5_15__leaf_clk sg13g2_dfrbpq_1
XFILLER_0_427 VPWR VGND sg13g2_decap_8
XFILLER_28_111 VPWR VGND sg13g2_decap_8
XFILLER_29_656 VPWR VGND sg13g2_decap_8
XFILLER_12_501 VPWR VGND sg13g2_decap_8
XFILLER_24_350 VPWR VGND sg13g2_decap_8
XFILLER_28_188 VPWR VGND sg13g2_decap_8
XFILLER_31_309 VPWR VGND sg13g2_decap_8
XFILLER_43_136 VPWR VGND sg13g2_decap_8
XFILLER_45_78 VPWR VGND sg13g2_decap_8
XFILLER_12_578 VPWR VGND sg13g2_decap_8
XFILLER_8_538 VPWR VGND sg13g2_decap_8
XFILLER_6_39 VPWR VGND sg13g2_decap_8
XFILLER_3_221 VPWR VGND sg13g2_decap_8
XFILLER_3_298 VPWR VGND sg13g2_decap_8
XFILLER_19_133 VPWR VGND sg13g2_decap_8
XFILLER_35_637 VPWR VGND sg13g2_decap_8
XFILLER_47_420 VPWR VGND sg13g2_decap_8
XFILLER_47_497 VPWR VGND sg13g2_decap_8
XFILLER_15_394 VPWR VGND sg13g2_decap_8
XFILLER_30_342 VPWR VGND sg13g2_decap_8
XFILLER_34_158 VPWR VGND sg13g2_decap_8
X_0714_ VGND VPWR net34 daisychain\[61\] _0447_ net35 sg13g2_a21oi_1
X_0645_ VGND VPWR net29 daisychain\[44\] _0395_ net50 sg13g2_a21oi_1
XFILLER_7_560 VPWR VGND sg13g2_fill_1
XFILLER_38_420 VPWR VGND sg13g2_decap_8
X_0576_ _0221_ net62 _0342_ _0343_ VPWR VGND sg13g2_a21o_1
XFILLER_15_37 VPWR VGND sg13g2_decap_8
XFILLER_25_125 VPWR VGND sg13g2_decap_8
XFILLER_38_497 VPWR VGND sg13g2_decap_8
XFILLER_40_117 VPWR VGND sg13g2_decap_8
XFILLER_21_353 VPWR VGND sg13g2_decap_8
XFILLER_5_508 VPWR VGND sg13g2_decap_8
XFILLER_0_224 VPWR VGND sg13g2_decap_8
XFILLER_1_725 VPWR VGND sg13g2_fill_1
Xoutput14 net14 uio_out[6] VPWR VGND sg13g2_buf_1
XFILLER_29_475 VPWR VGND sg13g2_decap_8
XFILLER_48_217 VPWR VGND sg13g2_decap_8
XFILLER_12_342 VPWR VGND sg13g2_decap_8
XFILLER_13_821 VPWR VGND sg13g2_fill_2
XFILLER_16_158 VPWR VGND sg13g2_decap_8
XFILLER_17_659 VPWR VGND sg13g2_fill_2
XFILLER_31_106 VPWR VGND sg13g2_decap_8
XFILLER_21_80 VPWR VGND sg13g2_decap_8
XFILLER_8_335 VPWR VGND sg13g2_decap_8
XFILLER_39_217 VPWR VGND sg13g2_decap_8
XFILLER_4_574 VPWR VGND sg13g2_fill_1
XFILLER_35_434 VPWR VGND sg13g2_decap_8
XFILLER_47_294 VPWR VGND sg13g2_decap_8
XFILLER_15_191 VPWR VGND sg13g2_decap_8
X_0628_ _0234_ net73 _0381_ _0382_ VPWR VGND sg13g2_a21o_1
X_0559_ net84 VPWR _0330_ VGND net64 state\[24\] sg13g2_o21ai_1
XFILLER_13_139 VPWR VGND sg13g2_decap_8
XFILLER_14_607 VPWR VGND sg13g2_decap_8
XFILLER_14_618 VPWR VGND sg13g2_fill_1
XFILLER_22_651 VPWR VGND sg13g2_decap_8
XFILLER_26_467 VPWR VGND sg13g2_decap_8
XFILLER_38_294 VPWR VGND sg13g2_decap_8
XFILLER_41_426 VPWR VGND sg13g2_decap_8
XFILLER_21_150 VPWR VGND sg13g2_decap_8
XFILLER_42_68 VPWR VGND sg13g2_decap_8
XFILLER_5_305 VPWR VGND sg13g2_decap_8
XFILLER_1_511 VPWR VGND sg13g2_decap_8
XFILLER_3_18 VPWR VGND sg13g2_decap_8
XFILLER_49_515 VPWR VGND sg13g2_decap_8
XFILLER_17_456 VPWR VGND sg13g2_decap_8
XFILLER_29_272 VPWR VGND sg13g2_decap_8
XFILLER_44_264 VPWR VGND sg13g2_decap_8
XFILLER_13_651 VPWR VGND sg13g2_fill_2
XFILLER_32_459 VPWR VGND sg13g2_decap_8
XFILLER_8_132 VPWR VGND sg13g2_decap_8
XFILLER_48_581 VPWR VGND sg13g2_decap_8
XFILLER_23_437 VPWR VGND sg13g2_decap_8
XFILLER_35_231 VPWR VGND sg13g2_decap_8
XFILLER_12_27 VPWR VGND sg13g2_decap_8
XFILLER_31_470 VPWR VGND sg13g2_decap_8
XFILLER_2_319 VPWR VGND sg13g2_decap_8
XFILLER_14_404 VPWR VGND sg13g2_decap_8
XFILLER_18_209 VPWR VGND sg13g2_decap_8
XFILLER_26_264 VPWR VGND sg13g2_decap_8
XFILLER_27_721 VPWR VGND sg13g2_decap_8
XFILLER_37_35 VPWR VGND sg13g2_decap_8
XFILLER_39_581 VPWR VGND sg13g2_decap_8
XFILLER_46_518 VPWR VGND sg13g2_decap_8
XFILLER_27_798 VPWR VGND sg13g2_fill_1
XFILLER_41_223 VPWR VGND sg13g2_decap_8
XFILLER_10_665 VPWR VGND sg13g2_decap_4
XFILLER_5_179 VPWR VGND sg13g2_decap_8
XFILLER_5_102 VPWR VGND sg13g2_decap_8
XFILLER_18_710 VPWR VGND sg13g2_fill_1
XFILLER_1_385 VPWR VGND sg13g2_decap_8
XFILLER_37_518 VPWR VGND sg13g2_decap_8
XFILLER_49_389 VPWR VGND sg13g2_decap_8
XFILLER_49_312 VPWR VGND sg13g2_decap_8
XFILLER_17_253 VPWR VGND sg13g2_decap_8
XFILLER_18_721 VPWR VGND sg13g2_decap_8
XFILLER_18_776 VPWR VGND sg13g2_decap_8
XFILLER_18_787 VPWR VGND sg13g2_fill_1
XFILLER_32_256 VPWR VGND sg13g2_decap_8
XFILLER_33_702 VPWR VGND sg13g2_fill_1
XFILLER_45_540 VPWR VGND sg13g2_decap_8
X_0893_ VPWR _0246_ daisychain\[53\] VGND sg13g2_inv_1
X_0962_ net100 VGND VPWR _0122_ daisychain\[58\] clknet_5_24__leaf_clk sg13g2_dfrbpq_1
XFILLER_9_452 VPWR VGND sg13g2_decap_8
XFILLER_4_83 VPWR VGND sg13g2_decap_8
XFILLER_23_15 VPWR VGND sg13g2_fill_1
XFILLER_23_234 VPWR VGND sg13g2_decap_8
XFILLER_36_595 VPWR VGND sg13g2_decap_8
XFILLER_2_116 VPWR VGND sg13g2_decap_8
XFILLER_19_518 VPWR VGND sg13g2_decap_8
XFILLER_46_315 VPWR VGND sg13g2_decap_8
XFILLER_48_56 VPWR VGND sg13g2_decap_8
XFILLER_14_201 VPWR VGND sg13g2_decap_8
XFILLER_27_595 VPWR VGND sg13g2_decap_8
XFILLER_42_565 VPWR VGND sg13g2_decap_8
XFILLER_10_440 VPWR VGND sg13g2_decap_8
XFILLER_14_278 VPWR VGND sg13g2_decap_8
Xfanout93 net98 net93 VPWR VGND sg13g2_buf_1
Xfanout82 net83 net82 VPWR VGND sg13g2_buf_1
Xfanout71 net77 net71 VPWR VGND sg13g2_buf_1
Xfanout60 net62 net60 VPWR VGND sg13g2_buf_1
XFILLER_9_39 VPWR VGND sg13g2_decap_8
XFILLER_36_7 VPWR VGND sg13g2_decap_8
XFILLER_6_466 VPWR VGND sg13g2_decap_8
XFILLER_1_182 VPWR VGND sg13g2_decap_8
XFILLER_29_6 VPWR VGND sg13g2_fill_1
XFILLER_37_315 VPWR VGND sg13g2_decap_8
XFILLER_49_186 VPWR VGND sg13g2_decap_8
XFILLER_14_790 VPWR VGND sg13g2_fill_1
XFILLER_18_573 VPWR VGND sg13g2_decap_8
XFILLER_20_248 VPWR VGND sg13g2_decap_8
XFILLER_33_543 VPWR VGND sg13g2_decap_8
X_0876_ VPWR _0004_ state\[45\] VGND sg13g2_inv_1
X_0945_ net115 VGND VPWR _0105_ daisychain\[41\] clknet_5_17__leaf_clk sg13g2_dfrbpq_1
XFILLER_29_816 VPWR VGND sg13g2_decap_8
XFILLER_18_48 VPWR VGND sg13g2_decap_8
XFILLER_24_532 VPWR VGND sg13g2_decap_8
XFILLER_34_25 VPWR VGND sg13g2_decap_8
XFILLER_36_392 VPWR VGND sg13g2_decap_8
XFILLER_43_318 VPWR VGND sg13g2_decap_8
XFILLER_3_403 VPWR VGND sg13g2_decap_8
XFILLER_19_315 VPWR VGND sg13g2_decap_8
XFILLER_46_112 VPWR VGND sg13g2_decap_8
XFILLER_47_602 VPWR VGND sg13g2_decap_8
XFILLER_47_668 VPWR VGND sg13g2_fill_2
XFILLER_15_576 VPWR VGND sg13g2_decap_8
XFILLER_27_392 VPWR VGND sg13g2_decap_8
XFILLER_30_524 VPWR VGND sg13g2_decap_8
XFILLER_46_189 VPWR VGND sg13g2_decap_8
XFILLER_24_91 VPWR VGND sg13g2_decap_8
X_0730_ _0289_ VPWR _0138_ VGND net84 _0033_ sg13g2_o21ai_1
X_0661_ VGND VPWR net30 daisychain\[48\] _0407_ net53 sg13g2_a21oi_1
XFILLER_6_263 VPWR VGND sg13g2_decap_8
XFILLER_2_480 VPWR VGND sg13g2_decap_8
XFILLER_34_4 VPWR VGND sg13g2_decap_8
XFILLER_38_602 VPWR VGND sg13g2_decap_8
X_0592_ _0225_ net73 _0354_ _0355_ VPWR VGND sg13g2_a21o_1
XFILLER_18_370 VPWR VGND sg13g2_decap_8
XFILLER_1_84 VPWR VGND sg13g2_decap_8
XFILLER_25_307 VPWR VGND sg13g2_decap_8
XFILLER_37_112 VPWR VGND sg13g2_decap_8
XFILLER_37_189 VPWR VGND sg13g2_decap_8
XFILLER_21_535 VPWR VGND sg13g2_decap_8
XFILLER_33_340 VPWR VGND sg13g2_decap_8
XFILLER_0_406 VPWR VGND sg13g2_decap_8
XFILLER_20_38 VPWR VGND sg13g2_decap_8
X_0859_ VPWR _0229_ daisychain\[36\] VGND sg13g2_inv_1
X_0928_ net106 VGND VPWR _0088_ daisychain\[24\] clknet_5_14__leaf_clk sg13g2_dfrbpq_1
XFILLER_29_635 VPWR VGND sg13g2_decap_8
XFILLER_29_69 VPWR VGND sg13g2_decap_8
XFILLER_28_167 VPWR VGND sg13g2_decap_8
XFILLER_43_115 VPWR VGND sg13g2_decap_8
XFILLER_45_57 VPWR VGND sg13g2_decap_8
XFILLER_12_557 VPWR VGND sg13g2_decap_8
XFILLER_3_200 VPWR VGND sg13g2_decap_8
XFILLER_8_517 VPWR VGND sg13g2_decap_8
XFILLER_6_18 VPWR VGND sg13g2_decap_8
XFILLER_4_701 VPWR VGND sg13g2_fill_1
XFILLER_3_277 VPWR VGND sg13g2_decap_8
XFILLER_19_112 VPWR VGND sg13g2_decap_8
XFILLER_19_189 VPWR VGND sg13g2_decap_8
XFILLER_19_91 VPWR VGND sg13g2_decap_8
XFILLER_34_137 VPWR VGND sg13g2_decap_8
XFILLER_35_616 VPWR VGND sg13g2_decap_8
XFILLER_47_476 VPWR VGND sg13g2_decap_8
XFILLER_15_373 VPWR VGND sg13g2_decap_8
XFILLER_30_321 VPWR VGND sg13g2_decap_8
XFILLER_30_398 VPWR VGND sg13g2_decap_8
XFILLER_31_811 VPWR VGND sg13g2_decap_8
XFILLER_31_822 VPWR VGND sg13g2_fill_1
XFILLER_43_693 VPWR VGND sg13g2_decap_8
XFILLER_11_590 VPWR VGND sg13g2_decap_8
X_0713_ VGND VPWR _0446_ _0445_ _0444_ sg13g2_or2_1
X_0644_ _0238_ net72 _0393_ _0394_ VPWR VGND sg13g2_a21o_1
X_0575_ net83 VPWR _0342_ VGND net62 state\[28\] sg13g2_o21ai_1
XFILLER_22_822 VPWR VGND sg13g2_fill_1
XFILLER_25_104 VPWR VGND sg13g2_decap_8
XFILLER_26_649 VPWR VGND sg13g2_decap_8
XFILLER_34_671 VPWR VGND sg13g2_fill_1
XFILLER_38_476 VPWR VGND sg13g2_decap_8
XFILLER_21_332 VPWR VGND sg13g2_decap_8
XFILLER_0_203 VPWR VGND sg13g2_decap_8
Xoutput15 net15 uio_out[7] VPWR VGND sg13g2_buf_1
XFILLER_16_137 VPWR VGND sg13g2_decap_8
XFILLER_17_638 VPWR VGND sg13g2_decap_8
XFILLER_29_454 VPWR VGND sg13g2_decap_8
XFILLER_44_446 VPWR VGND sg13g2_decap_8
XFILLER_12_321 VPWR VGND sg13g2_decap_8
XFILLER_13_800 VPWR VGND sg13g2_decap_4
XFILLER_8_314 VPWR VGND sg13g2_decap_8
XFILLER_4_531 VPWR VGND sg13g2_decap_8
Xdigitalen0.g\[0\].u.inv1 VPWR digitalen0.g\[0\].u.OUTN net6 VGND sg13g2_inv_1
XFILLER_15_170 VPWR VGND sg13g2_decap_8
XFILLER_23_619 VPWR VGND sg13g2_decap_8
XFILLER_35_413 VPWR VGND sg13g2_decap_8
XFILLER_47_273 VPWR VGND sg13g2_decap_8
XFILLER_30_195 VPWR VGND sg13g2_decap_8
X_0627_ net95 VPWR _0381_ VGND net73 state\[41\] sg13g2_o21ai_1
X_0558_ _0087_ _0328_ _0329_ net42 _0216_ VPWR VGND sg13g2_a22oi_1
XFILLER_26_446 VPWR VGND sg13g2_decap_8
XFILLER_38_273 VPWR VGND sg13g2_decap_8
X_0489_ VGND VPWR net24 daisychain\[5\] _0278_ net39 sg13g2_a21oi_1
XFILLER_13_118 VPWR VGND sg13g2_decap_8
XFILLER_22_630 VPWR VGND sg13g2_decap_8
XFILLER_41_405 VPWR VGND sg13g2_decap_8
XFILLER_42_14 VPWR VGND sg13g2_decap_8
XFILLER_42_47 VPWR VGND sg13g2_decap_8
XFILLER_1_567 VPWR VGND sg13g2_fill_2
XFILLER_17_435 VPWR VGND sg13g2_decap_8
XFILLER_29_251 VPWR VGND sg13g2_decap_8
XFILLER_32_438 VPWR VGND sg13g2_decap_8
XFILLER_44_243 VPWR VGND sg13g2_decap_8
XFILLER_12_195 VPWR VGND sg13g2_decap_8
XFILLER_13_630 VPWR VGND sg13g2_fill_1
XFILLER_16_81 VPWR VGND sg13g2_decap_8
XFILLER_8_188 VPWR VGND sg13g2_decap_8
XFILLER_8_111 VPWR VGND sg13g2_decap_8
XFILLER_35_210 VPWR VGND sg13g2_decap_8
XFILLER_48_560 VPWR VGND sg13g2_decap_8
XFILLER_23_416 VPWR VGND sg13g2_decap_8
XFILLER_35_287 VPWR VGND sg13g2_decap_8
XFILLER_37_14 VPWR VGND sg13g2_decap_8
XFILLER_26_243 VPWR VGND sg13g2_decap_8
XFILLER_27_700 VPWR VGND sg13g2_decap_8
XFILLER_41_202 VPWR VGND sg13g2_decap_8
XFILLER_10_611 VPWR VGND sg13g2_fill_2
XFILLER_41_279 VPWR VGND sg13g2_decap_8
XFILLER_10_699 VPWR VGND sg13g2_fill_1
XFILLER_2_821 VPWR VGND sg13g2_fill_2
XFILLER_5_158 VPWR VGND sg13g2_decap_8
XFILLER_1_364 VPWR VGND sg13g2_decap_8
XFILLER_49_368 VPWR VGND sg13g2_decap_8
XFILLER_17_232 VPWR VGND sg13g2_decap_8
XFILLER_27_91 VPWR VGND sg13g2_decap_8
XFILLER_32_235 VPWR VGND sg13g2_decap_8
XFILLER_45_596 VPWR VGND sg13g2_decap_8
X_0961_ net100 VGND VPWR _0121_ daisychain\[57\] clknet_5_24__leaf_clk sg13g2_dfrbpq_1
XFILLER_13_493 VPWR VGND sg13g2_decap_8
X_0892_ VPWR _0013_ state\[53\] VGND sg13g2_inv_1
XFILLER_9_431 VPWR VGND sg13g2_decap_8
XFILLER_4_62 VPWR VGND sg13g2_decap_8
XFILLER_23_213 VPWR VGND sg13g2_decap_8
XFILLER_36_574 VPWR VGND sg13g2_decap_8
XFILLER_32_780 VPWR VGND sg13g2_fill_2
Xclkbuf_5_18__f_clk clknet_5_18__leaf_clk clknet_4_9_0_clk VPWR VGND sg13g2_buf_16
XFILLER_48_35 VPWR VGND sg13g2_decap_8
XFILLER_14_257 VPWR VGND sg13g2_decap_8
XFILLER_27_574 VPWR VGND sg13g2_decap_8
XFILLER_30_706 VPWR VGND sg13g2_decap_8
XFILLER_42_544 VPWR VGND sg13g2_decap_8
XFILLER_9_18 VPWR VGND sg13g2_decap_8
XFILLER_10_496 VPWR VGND sg13g2_decap_8
Xfanout94 net95 net94 VPWR VGND sg13g2_buf_1
Xfanout83 net89 net83 VPWR VGND sg13g2_buf_1
Xfanout72 net73 net72 VPWR VGND sg13g2_buf_1
Xfanout61 net62 net61 VPWR VGND sg13g2_buf_1
Xfanout50 net51 net50 VPWR VGND sg13g2_buf_1
XFILLER_6_445 VPWR VGND sg13g2_decap_8
XFILLER_1_161 VPWR VGND sg13g2_decap_8
XFILLER_18_552 VPWR VGND sg13g2_decap_8
XFILLER_33_522 VPWR VGND sg13g2_decap_8
XFILLER_49_165 VPWR VGND sg13g2_decap_8
XFILLER_20_227 VPWR VGND sg13g2_decap_8
XFILLER_33_599 VPWR VGND sg13g2_decap_8
XFILLER_45_393 VPWR VGND sg13g2_decap_8
X_0944_ net115 VGND VPWR _0104_ daisychain\[40\] clknet_5_16__leaf_clk sg13g2_dfrbpq_1
X_0875_ VPWR _0237_ daisychain\[44\] VGND sg13g2_inv_1
XFILLER_24_511 VPWR VGND sg13g2_decap_8
XFILLER_24_588 VPWR VGND sg13g2_decap_8
XFILLER_28_349 VPWR VGND sg13g2_decap_8
XFILLER_36_371 VPWR VGND sg13g2_decap_8
XFILLER_11_249 VPWR VGND sg13g2_decap_8
XFILLER_20_783 VPWR VGND sg13g2_decap_8
XFILLER_3_459 VPWR VGND sg13g2_decap_8
XFILLER_27_371 VPWR VGND sg13g2_decap_8
XFILLER_34_319 VPWR VGND sg13g2_decap_8
XFILLER_46_168 VPWR VGND sg13g2_decap_8
XFILLER_15_555 VPWR VGND sg13g2_decap_8
XFILLER_24_70 VPWR VGND sg13g2_decap_8
XFILLER_30_503 VPWR VGND sg13g2_decap_8
XFILLER_42_385 VPWR VGND sg13g2_decap_8
XFILLER_10_293 VPWR VGND sg13g2_decap_8
X_0660_ _0242_ net75 _0405_ _0406_ VPWR VGND sg13g2_a21o_1
X_0591_ net95 VPWR _0354_ VGND net73 state\[32\] sg13g2_o21ai_1
XFILLER_6_242 VPWR VGND sg13g2_decap_8
XFILLER_1_63 VPWR VGND sg13g2_decap_8
XFILLER_37_168 VPWR VGND sg13g2_decap_8
XFILLER_45_190 VPWR VGND sg13g2_decap_8
XFILLER_21_514 VPWR VGND sg13g2_decap_8
XFILLER_33_396 VPWR VGND sg13g2_decap_8
X_0927_ net109 VGND VPWR _0087_ daisychain\[23\] clknet_5_2__leaf_clk sg13g2_dfrbpq_1
X_0858_ VPWR _0026_ state\[36\] VGND sg13g2_inv_1
X_0789_ VPWR _0194_ daisychain\[1\] VGND sg13g2_inv_1
XFILLER_16_319 VPWR VGND sg13g2_decap_8
XFILLER_25_820 VPWR VGND sg13g2_fill_2
XFILLER_28_146 VPWR VGND sg13g2_decap_8
XFILLER_29_48 VPWR VGND sg13g2_decap_8
XFILLER_29_614 VPWR VGND sg13g2_decap_8
XFILLER_45_14 VPWR VGND sg13g2_decap_8
XFILLER_45_36 VPWR VGND sg13g2_decap_8
XFILLER_12_536 VPWR VGND sg13g2_decap_8
XFILLER_24_385 VPWR VGND sg13g2_decap_8
XFILLER_20_591 VPWR VGND sg13g2_decap_8
XFILLER_10_83 VPWR VGND sg13g2_decap_8
XFILLER_3_256 VPWR VGND sg13g2_decap_8
XFILLER_15_352 VPWR VGND sg13g2_decap_8
XFILLER_19_168 VPWR VGND sg13g2_decap_8
XFILLER_19_70 VPWR VGND sg13g2_decap_8
XFILLER_28_691 VPWR VGND sg13g2_decap_8
XFILLER_34_116 VPWR VGND sg13g2_decap_8
XFILLER_43_672 VPWR VGND sg13g2_fill_1
XFILLER_47_455 VPWR VGND sg13g2_decap_8
XFILLER_30_300 VPWR VGND sg13g2_decap_8
XFILLER_30_377 VPWR VGND sg13g2_decap_8
XFILLER_35_91 VPWR VGND sg13g2_decap_8
XFILLER_42_182 VPWR VGND sg13g2_decap_8
X_0712_ net80 VPWR _0445_ VGND net57 state\[62\] sg13g2_o21ai_1
X_0643_ net94 VPWR _0393_ VGND net72 state\[45\] sg13g2_o21ai_1
X_0574_ _0091_ _0340_ _0341_ net40 _0220_ VPWR VGND sg13g2_a22oi_1
XFILLER_26_628 VPWR VGND sg13g2_decap_8
XFILLER_38_455 VPWR VGND sg13g2_decap_8
XFILLER_21_311 VPWR VGND sg13g2_decap_8
XFILLER_33_193 VPWR VGND sg13g2_decap_8
XFILLER_21_388 VPWR VGND sg13g2_decap_8
XFILLER_0_259 VPWR VGND sg13g2_decap_8
Xoutput16 net16 uo_out[0] VPWR VGND sg13g2_buf_1
XFILLER_16_116 VPWR VGND sg13g2_decap_8
XFILLER_17_617 VPWR VGND sg13g2_decap_8
XFILLER_29_433 VPWR VGND sg13g2_decap_8
XFILLER_44_425 VPWR VGND sg13g2_decap_8
XFILLER_12_300 VPWR VGND sg13g2_decap_8
XFILLER_12_377 VPWR VGND sg13g2_decap_8
XFILLER_13_812 VPWR VGND sg13g2_fill_2
XFILLER_24_182 VPWR VGND sg13g2_decap_8
XFILLER_25_683 VPWR VGND sg13g2_decap_8
XFILLER_40_620 VPWR VGND sg13g2_decap_8
Xdigitalen0.g\[0\].u.inv2 VPWR digitalen0.g\[0\].u.OUTP digitalen0.g\[0\].u.OUTN VGND
+ sg13g2_inv_1
XFILLER_4_510 VPWR VGND sg13g2_decap_8
XFILLER_0_760 VPWR VGND sg13g2_fill_1
XFILLER_47_252 VPWR VGND sg13g2_decap_8
XFILLER_22_119 VPWR VGND sg13g2_decap_8
XFILLER_31_631 VPWR VGND sg13g2_decap_8
XFILLER_35_469 VPWR VGND sg13g2_decap_8
XFILLER_43_491 VPWR VGND sg13g2_decap_8
Xclkbuf_0_clk clknet_0_clk clk VPWR VGND sg13g2_buf_16
XFILLER_30_174 VPWR VGND sg13g2_decap_8
XFILLER_7_84 VPWR VGND sg13g2_decap_8
XFILLER_7_392 VPWR VGND sg13g2_decap_8
X_0626_ _0104_ _0379_ _0380_ net51 _0233_ VPWR VGND sg13g2_a22oi_1
X_0557_ VGND VPWR net26 daisychain\[22\] _0329_ net42 sg13g2_a21oi_1
XFILLER_26_27 VPWR VGND sg13g2_fill_2
XFILLER_26_425 VPWR VGND sg13g2_decap_8
XFILLER_38_252 VPWR VGND sg13g2_decap_8
X_0488_ _0199_ net60 _0276_ _0277_ VPWR VGND sg13g2_a21o_1
XFILLER_21_185 VPWR VGND sg13g2_decap_8
XFILLER_22_686 VPWR VGND sg13g2_decap_8
XFILLER_34_480 VPWR VGND sg13g2_decap_8
XFILLER_1_546 VPWR VGND sg13g2_decap_8
XFILLER_29_230 VPWR VGND sg13g2_decap_8
XFILLER_16_60 VPWR VGND sg13g2_decap_8
XFILLER_17_414 VPWR VGND sg13g2_decap_8
XFILLER_25_480 VPWR VGND sg13g2_decap_8
XFILLER_32_417 VPWR VGND sg13g2_decap_8
XFILLER_44_222 VPWR VGND sg13g2_decap_8
XFILLER_44_299 VPWR VGND sg13g2_decap_8
Xdigitalen1.g\[2\].u.inv1 VPWR digitalen1.g\[2\].u.OUTN net7 VGND sg13g2_inv_1
XFILLER_12_174 VPWR VGND sg13g2_decap_8
XFILLER_32_81 VPWR VGND sg13g2_decap_8
XFILLER_40_461 VPWR VGND sg13g2_decap_4
XFILLER_9_646 VPWR VGND sg13g2_fill_1
XFILLER_9_613 VPWR VGND sg13g2_fill_2
XFILLER_8_167 VPWR VGND sg13g2_decap_8
XFILLER_4_384 VPWR VGND sg13g2_decap_8
XFILLER_36_767 VPWR VGND sg13g2_decap_8
XFILLER_16_480 VPWR VGND sg13g2_decap_8
XFILLER_35_266 VPWR VGND sg13g2_decap_8
XFILLER_8_690 VPWR VGND sg13g2_fill_1
X_0609_ VGND VPWR net28 daisychain\[35\] _0368_ net48 sg13g2_a21oi_1
XFILLER_14_439 VPWR VGND sg13g2_decap_8
XFILLER_26_222 VPWR VGND sg13g2_decap_8
XFILLER_26_299 VPWR VGND sg13g2_decap_8
XFILLER_22_483 VPWR VGND sg13g2_decap_8
XFILLER_41_258 VPWR VGND sg13g2_decap_8
XFILLER_6_627 VPWR VGND sg13g2_decap_4
XFILLER_5_137 VPWR VGND sg13g2_decap_8
XFILLER_1_343 VPWR VGND sg13g2_decap_8
XFILLER_2_811 VPWR VGND sg13g2_decap_4
XFILLER_17_211 VPWR VGND sg13g2_decap_8
XFILLER_27_70 VPWR VGND sg13g2_decap_8
XFILLER_49_347 VPWR VGND sg13g2_decap_8
XFILLER_13_472 VPWR VGND sg13g2_decap_8
XFILLER_17_288 VPWR VGND sg13g2_decap_8
XFILLER_20_409 VPWR VGND sg13g2_decap_8
XFILLER_32_214 VPWR VGND sg13g2_decap_8
XFILLER_43_80 VPWR VGND sg13g2_decap_8
XFILLER_45_575 VPWR VGND sg13g2_decap_8
X_0960_ net119 VGND VPWR _0120_ daisychain\[56\] clknet_5_24__leaf_clk sg13g2_dfrbpq_1
XFILLER_9_410 VPWR VGND sg13g2_decap_8
X_0891_ VPWR _0245_ daisychain\[52\] VGND sg13g2_inv_1
XFILLER_9_487 VPWR VGND sg13g2_decap_8
XFILLER_4_41 VPWR VGND sg13g2_decap_8
XFILLER_4_181 VPWR VGND sg13g2_decap_8
XFILLER_24_715 VPWR VGND sg13g2_decap_8
XFILLER_36_553 VPWR VGND sg13g2_decap_8
XFILLER_23_269 VPWR VGND sg13g2_decap_8
XFILLER_48_14 VPWR VGND sg13g2_decap_8
XFILLER_27_553 VPWR VGND sg13g2_decap_8
XFILLER_14_236 VPWR VGND sg13g2_decap_8
XFILLER_42_523 VPWR VGND sg13g2_decap_8
Xfanout73 net76 net73 VPWR VGND sg13g2_buf_1
Xfanout62 net68 net62 VPWR VGND sg13g2_buf_1
Xfanout51 net54 net51 VPWR VGND sg13g2_buf_1
Xfanout40 net55 net40 VPWR VGND sg13g2_buf_1
XFILLER_10_475 VPWR VGND sg13g2_decap_8
XFILLER_13_83 VPWR VGND sg13g2_decap_8
XFILLER_22_280 VPWR VGND sg13g2_decap_8
Xfanout95 net98 net95 VPWR VGND sg13g2_buf_1
Xfanout84 net85 net84 VPWR VGND sg13g2_buf_1
XFILLER_6_424 VPWR VGND sg13g2_decap_8
XFILLER_1_140 VPWR VGND sg13g2_decap_8
XFILLER_49_144 VPWR VGND sg13g2_decap_8
XFILLER_18_531 VPWR VGND sg13g2_decap_8
XFILLER_33_501 VPWR VGND sg13g2_decap_8
XFILLER_38_91 VPWR VGND sg13g2_decap_8
XFILLER_45_372 VPWR VGND sg13g2_decap_8
Xclkbuf_5_24__f_clk clknet_5_24__leaf_clk clknet_4_12_0_clk VPWR VGND sg13g2_buf_16
XFILLER_20_206 VPWR VGND sg13g2_decap_8
XFILLER_21_707 VPWR VGND sg13g2_fill_2
XFILLER_21_729 VPWR VGND sg13g2_decap_8
XFILLER_33_578 VPWR VGND sg13g2_decap_8
X_0874_ VPWR _0003_ state\[44\] VGND sg13g2_inv_1
X_0943_ net116 VGND VPWR _0103_ daisychain\[39\] clknet_5_22__leaf_clk sg13g2_dfrbpq_1
XFILLER_9_284 VPWR VGND sg13g2_decap_8
XFILLER_48_0 VPWR VGND sg13g2_decap_8
XFILLER_28_328 VPWR VGND sg13g2_decap_8
XFILLER_11_228 VPWR VGND sg13g2_decap_8
XFILLER_24_567 VPWR VGND sg13g2_decap_8
XFILLER_36_350 VPWR VGND sg13g2_decap_8
XFILLER_3_438 VPWR VGND sg13g2_decap_8
XFILLER_15_534 VPWR VGND sg13g2_decap_8
XFILLER_27_350 VPWR VGND sg13g2_decap_8
XFILLER_46_147 VPWR VGND sg13g2_decap_8
XFILLER_30_559 VPWR VGND sg13g2_decap_8
XFILLER_42_364 VPWR VGND sg13g2_decap_8
XFILLER_10_272 VPWR VGND sg13g2_decap_8
XFILLER_41_7 VPWR VGND sg13g2_decap_8
X_0590_ _0095_ _0352_ _0353_ net42 _0224_ VPWR VGND sg13g2_a22oi_1
XFILLER_6_298 VPWR VGND sg13g2_decap_8
XFILLER_6_221 VPWR VGND sg13g2_decap_8
XFILLER_1_42 VPWR VGND sg13g2_decap_8
XFILLER_37_147 VPWR VGND sg13g2_decap_8
XFILLER_33_375 VPWR VGND sg13g2_decap_8
X_0926_ net109 VGND VPWR _0086_ daisychain\[22\] clknet_5_2__leaf_clk sg13g2_dfrbpq_1
X_0857_ VPWR _0228_ daisychain\[35\] VGND sg13g2_inv_1
XFILLER_29_27 VPWR VGND sg13g2_decap_8
X_0788_ VPWR _0043_ state\[1\] VGND sg13g2_inv_1
XFILLER_28_125 VPWR VGND sg13g2_decap_8
XFILLER_37_670 VPWR VGND sg13g2_decap_4
XFILLER_12_515 VPWR VGND sg13g2_decap_8
XFILLER_20_570 VPWR VGND sg13g2_decap_8
XFILLER_24_364 VPWR VGND sg13g2_decap_8
XFILLER_10_62 VPWR VGND sg13g2_decap_8
XFILLER_3_235 VPWR VGND sg13g2_decap_8
XFILLER_19_147 VPWR VGND sg13g2_decap_8
XFILLER_47_434 VPWR VGND sg13g2_decap_8
XFILLER_15_331 VPWR VGND sg13g2_decap_8
XFILLER_28_670 VPWR VGND sg13g2_decap_8
XFILLER_35_70 VPWR VGND sg13g2_decap_8
XFILLER_43_662 VPWR VGND sg13g2_fill_2
XFILLER_30_356 VPWR VGND sg13g2_decap_8
X_0711_ daisychain\[62\] net57 _0444_ VPWR VGND sg13g2_nor2b_1
X_0642_ _0108_ _0391_ _0392_ net50 _0237_ VPWR VGND sg13g2_a22oi_1
X_0573_ VGND VPWR net24 daisychain\[26\] _0341_ net39 sg13g2_a21oi_1
XFILLER_19_681 VPWR VGND sg13g2_fill_1
XFILLER_25_139 VPWR VGND sg13g2_decap_8
XFILLER_26_607 VPWR VGND sg13g2_decap_8
XFILLER_38_434 VPWR VGND sg13g2_decap_8
XFILLER_21_367 VPWR VGND sg13g2_decap_8
XFILLER_33_172 VPWR VGND sg13g2_decap_8
XFILLER_34_662 VPWR VGND sg13g2_decap_8
XFILLER_34_684 VPWR VGND sg13g2_fill_2
X_0909_ net103 VGND VPWR _0069_ daisychain\[5\] clknet_5_12__leaf_clk sg13g2_dfrbpq_1
Xoutput17 net17 uo_out[1] VPWR VGND sg13g2_buf_1
XFILLER_0_238 VPWR VGND sg13g2_decap_8
XFILLER_29_412 VPWR VGND sg13g2_decap_8
XFILLER_24_161 VPWR VGND sg13g2_decap_8
XFILLER_25_662 VPWR VGND sg13g2_decap_8
XFILLER_29_489 VPWR VGND sg13g2_decap_8
XFILLER_44_404 VPWR VGND sg13g2_decap_8
XFILLER_44_459 VPWR VGND sg13g2_decap_8
XFILLER_12_356 VPWR VGND sg13g2_decap_8
XFILLER_8_349 VPWR VGND sg13g2_decap_8
XFILLER_21_94 VPWR VGND sg13g2_decap_8
XFILLER_47_231 VPWR VGND sg13g2_decap_8
XFILLER_16_662 VPWR VGND sg13g2_fill_2
XFILLER_16_684 VPWR VGND sg13g2_decap_4
XFILLER_30_153 VPWR VGND sg13g2_decap_8
XFILLER_31_610 VPWR VGND sg13g2_decap_8
XFILLER_35_448 VPWR VGND sg13g2_decap_8
XFILLER_46_91 VPWR VGND sg13g2_decap_8
X_0625_ VGND VPWR net30 daisychain\[39\] _0380_ net52 sg13g2_a21oi_1
XFILLER_7_63 VPWR VGND sg13g2_decap_8
XFILLER_7_371 VPWR VGND sg13g2_decap_8
XFILLER_30_0 VPWR VGND sg13g2_fill_2
XFILLER_39_710 VPWR VGND sg13g2_fill_1
X_0556_ _0216_ net67 _0327_ _0328_ VPWR VGND sg13g2_a21o_1
X_0487_ net82 VPWR _0276_ VGND net60 state\[6\] sg13g2_o21ai_1
XFILLER_26_404 VPWR VGND sg13g2_decap_8
XFILLER_38_231 VPWR VGND sg13g2_decap_8
XFILLER_21_164 VPWR VGND sg13g2_decap_8
XFILLER_22_665 VPWR VGND sg13g2_decap_8
XFILLER_5_319 VPWR VGND sg13g2_decap_8
XFILLER_1_525 VPWR VGND sg13g2_decap_8
XFILLER_1_569 VPWR VGND sg13g2_fill_1
XFILLER_29_286 VPWR VGND sg13g2_decap_8
XFILLER_44_201 VPWR VGND sg13g2_decap_8
Xclkbuf_5_5__f_clk clknet_5_5__leaf_clk clknet_4_2_0_clk VPWR VGND sg13g2_buf_16
XFILLER_49_529 VPWR VGND sg13g2_decap_8
XFILLER_12_153 VPWR VGND sg13g2_decap_8
XFILLER_40_440 VPWR VGND sg13g2_decap_8
XFILLER_44_278 VPWR VGND sg13g2_decap_8
Xdigitalen1.g\[2\].u.inv2 VPWR digitalen1.g\[2\].u.OUTP digitalen1.g\[2\].u.OUTN VGND
+ sg13g2_inv_1
XFILLER_32_60 VPWR VGND sg13g2_decap_8
XFILLER_8_146 VPWR VGND sg13g2_decap_8
XFILLER_4_363 VPWR VGND sg13g2_decap_8
XFILLER_35_245 VPWR VGND sg13g2_decap_8
XFILLER_36_702 VPWR VGND sg13g2_fill_2
XFILLER_48_595 VPWR VGND sg13g2_decap_8
XFILLER_31_484 VPWR VGND sg13g2_decap_8
X_0608_ _0229_ net70 _0366_ _0367_ VPWR VGND sg13g2_a21o_1
XFILLER_26_201 VPWR VGND sg13g2_decap_8
XFILLER_27_735 VPWR VGND sg13g2_decap_4
XFILLER_37_49 VPWR VGND sg13g2_decap_8
XFILLER_39_595 VPWR VGND sg13g2_decap_8
X_0539_ net86 VPWR _0315_ VGND net65 state\[19\] sg13g2_o21ai_1
XFILLER_14_418 VPWR VGND sg13g2_decap_8
XFILLER_22_462 VPWR VGND sg13g2_decap_8
XFILLER_26_278 VPWR VGND sg13g2_decap_8
XFILLER_41_237 VPWR VGND sg13g2_decap_8
XFILLER_42_727 VPWR VGND sg13g2_decap_8
XFILLER_5_116 VPWR VGND sg13g2_decap_8
XFILLER_1_322 VPWR VGND sg13g2_decap_8
XFILLER_1_399 VPWR VGND sg13g2_decap_8
XFILLER_2_801 VPWR VGND sg13g2_decap_4
XFILLER_49_326 VPWR VGND sg13g2_decap_8
XFILLER_17_267 VPWR VGND sg13g2_decap_8
XFILLER_45_554 VPWR VGND sg13g2_decap_8
XFILLER_13_451 VPWR VGND sg13g2_decap_8
X_0890_ VPWR _0012_ state\[52\] VGND sg13g2_inv_1
XFILLER_9_466 VPWR VGND sg13g2_decap_8
XFILLER_4_160 VPWR VGND sg13g2_decap_8
XFILLER_4_97 VPWR VGND sg13g2_decap_8
XFILLER_23_248 VPWR VGND sg13g2_decap_8
XFILLER_36_532 VPWR VGND sg13g2_decap_8
XFILLER_48_392 VPWR VGND sg13g2_decap_8
XFILLER_31_281 VPWR VGND sg13g2_decap_8
XFILLER_27_532 VPWR VGND sg13g2_decap_8
XFILLER_39_392 VPWR VGND sg13g2_decap_8
XFILLER_46_329 VPWR VGND sg13g2_decap_8
XFILLER_14_215 VPWR VGND sg13g2_decap_8
XFILLER_42_579 VPWR VGND sg13g2_decap_8
Xfanout30 net31 net30 VPWR VGND sg13g2_buf_1
Xfanout96 net97 net96 VPWR VGND sg13g2_buf_1
Xfanout85 net89 net85 VPWR VGND sg13g2_buf_1
Xfanout74 net76 net74 VPWR VGND sg13g2_buf_1
Xfanout63 net64 net63 VPWR VGND sg13g2_buf_1
Xfanout52 net54 net52 VPWR VGND sg13g2_buf_1
Xfanout41 net46 net41 VPWR VGND sg13g2_buf_1
XFILLER_10_454 VPWR VGND sg13g2_decap_8
XFILLER_13_62 VPWR VGND sg13g2_decap_8
XFILLER_6_403 VPWR VGND sg13g2_decap_8
XFILLER_18_510 VPWR VGND sg13g2_decap_8
XFILLER_1_196 VPWR VGND sg13g2_decap_8
XFILLER_2_686 VPWR VGND sg13g2_fill_2
XFILLER_37_329 VPWR VGND sg13g2_decap_8
XFILLER_38_70 VPWR VGND sg13g2_decap_8
XFILLER_49_123 VPWR VGND sg13g2_decap_8
XFILLER_18_587 VPWR VGND sg13g2_decap_8
XFILLER_33_557 VPWR VGND sg13g2_decap_8
XFILLER_45_351 VPWR VGND sg13g2_decap_8
XFILLER_14_782 VPWR VGND sg13g2_fill_1
X_0873_ VPWR _0236_ daisychain\[43\] VGND sg13g2_inv_1
X_0942_ net111 VGND VPWR _0102_ daisychain\[38\] clknet_5_28__leaf_clk sg13g2_dfrbpq_1
XFILLER_9_263 VPWR VGND sg13g2_decap_8
XFILLER_5_480 VPWR VGND sg13g2_decap_8
XFILLER_28_307 VPWR VGND sg13g2_decap_8
XFILLER_11_207 VPWR VGND sg13g2_decap_8
XFILLER_24_546 VPWR VGND sg13g2_decap_8
XFILLER_34_39 VPWR VGND sg13g2_decap_8
XFILLER_3_417 VPWR VGND sg13g2_decap_8
Xclkbuf_5_30__f_clk clknet_5_30__leaf_clk clknet_4_15_0_clk VPWR VGND sg13g2_buf_16
XFILLER_19_329 VPWR VGND sg13g2_decap_8
XFILLER_1_7 VPWR VGND sg13g2_decap_8
XFILLER_47_616 VPWR VGND sg13g2_decap_4
XFILLER_15_513 VPWR VGND sg13g2_decap_8
XFILLER_42_343 VPWR VGND sg13g2_decap_8
XFILLER_46_126 VPWR VGND sg13g2_decap_8
XFILLER_10_251 VPWR VGND sg13g2_decap_8
XFILLER_30_538 VPWR VGND sg13g2_decap_8
XFILLER_6_200 VPWR VGND sg13g2_decap_8
XFILLER_40_82 VPWR VGND sg13g2_decap_8
XFILLER_6_277 VPWR VGND sg13g2_decap_8
XFILLER_1_21 VPWR VGND sg13g2_decap_8
XFILLER_1_98 VPWR VGND sg13g2_decap_8
XFILLER_2_494 VPWR VGND sg13g2_decap_8
XFILLER_34_811 VPWR VGND sg13g2_decap_8
XFILLER_37_126 VPWR VGND sg13g2_decap_8
XFILLER_38_616 VPWR VGND sg13g2_decap_8
XFILLER_38_627 VPWR VGND sg13g2_fill_2
XFILLER_18_384 VPWR VGND sg13g2_decap_8
XFILLER_21_549 VPWR VGND sg13g2_decap_8
XFILLER_33_354 VPWR VGND sg13g2_decap_8
XFILLER_34_822 VPWR VGND sg13g2_fill_1
X_0925_ net109 VGND VPWR _0085_ daisychain\[21\] clknet_5_1__leaf_clk sg13g2_dfrbpq_1
X_0856_ VPWR _0025_ state\[35\] VGND sg13g2_inv_1
X_0787_ VPWR _0193_ daisychain\[0\] VGND sg13g2_inv_1
XFILLER_28_104 VPWR VGND sg13g2_decap_8
XFILLER_24_343 VPWR VGND sg13g2_decap_8
XFILLER_25_822 VPWR VGND sg13g2_fill_1
XFILLER_29_649 VPWR VGND sg13g2_decap_8
XFILLER_43_129 VPWR VGND sg13g2_decap_8
XFILLER_10_41 VPWR VGND sg13g2_decap_8
XFILLER_3_214 VPWR VGND sg13g2_decap_8
XFILLER_19_126 VPWR VGND sg13g2_decap_8
XFILLER_47_413 VPWR VGND sg13g2_decap_8
XFILLER_15_310 VPWR VGND sg13g2_decap_8
XFILLER_15_387 VPWR VGND sg13g2_decap_8
XFILLER_16_822 VPWR VGND sg13g2_fill_1
XFILLER_30_335 VPWR VGND sg13g2_decap_8
X_0710_ _0125_ _0442_ _0443_ net35 _0254_ VPWR VGND sg13g2_a22oi_1
X_0641_ VGND VPWR net29 daisychain\[43\] _0392_ net50 sg13g2_a21oi_1
XFILLER_7_553 VPWR VGND sg13g2_decap_8
XFILLER_2_291 VPWR VGND sg13g2_decap_8
XFILLER_32_4 VPWR VGND sg13g2_decap_8
XFILLER_38_413 VPWR VGND sg13g2_decap_8
X_0572_ _0220_ net60 _0339_ _0340_ VPWR VGND sg13g2_a21o_1
XFILLER_18_181 VPWR VGND sg13g2_decap_8
XFILLER_25_118 VPWR VGND sg13g2_decap_8
XFILLER_34_641 VPWR VGND sg13g2_decap_8
XFILLER_46_490 VPWR VGND sg13g2_decap_8
X_1055_ daisychain\[63\] net23 VPWR VGND sg13g2_buf_1
XFILLER_21_346 VPWR VGND sg13g2_decap_8
XFILLER_33_151 VPWR VGND sg13g2_decap_8
XFILLER_0_217 VPWR VGND sg13g2_decap_8
X_0908_ net102 VGND VPWR _0068_ daisychain\[4\] clknet_5_12__leaf_clk sg13g2_dfrbpq_1
Xoutput18 net18 uo_out[2] VPWR VGND sg13g2_buf_1
X_0839_ VPWR _0219_ daisychain\[26\] VGND sg13g2_inv_1
XFILLER_29_468 VPWR VGND sg13g2_decap_8
XFILLER_12_335 VPWR VGND sg13g2_decap_8
XFILLER_24_140 VPWR VGND sg13g2_decap_8
XFILLER_25_641 VPWR VGND sg13g2_decap_8
XFILLER_37_490 VPWR VGND sg13g2_decap_8
XFILLER_21_73 VPWR VGND sg13g2_decap_8
XFILLER_8_328 VPWR VGND sg13g2_decap_8
XFILLER_0_740 VPWR VGND sg13g2_fill_2
XFILLER_16_641 VPWR VGND sg13g2_decap_8
XFILLER_35_427 VPWR VGND sg13g2_decap_8
XFILLER_46_70 VPWR VGND sg13g2_decap_8
XFILLER_47_210 VPWR VGND sg13g2_decap_8
XFILLER_47_287 VPWR VGND sg13g2_decap_8
XFILLER_15_184 VPWR VGND sg13g2_decap_8
XFILLER_30_132 VPWR VGND sg13g2_decap_8
X_0624_ _0233_ net73 _0378_ _0379_ VPWR VGND sg13g2_a21o_1
XFILLER_7_42 VPWR VGND sg13g2_decap_8
XFILLER_7_350 VPWR VGND sg13g2_decap_8
XFILLER_38_210 VPWR VGND sg13g2_decap_8
X_0555_ net88 VPWR _0327_ VGND net67 state\[23\] sg13g2_o21ai_1
X_0486_ _0069_ _0274_ _0275_ net39 _0198_ VPWR VGND sg13g2_a22oi_1
XFILLER_19_490 VPWR VGND sg13g2_decap_8
XFILLER_22_644 VPWR VGND sg13g2_decap_8
XFILLER_38_287 VPWR VGND sg13g2_decap_8
XFILLER_41_419 VPWR VGND sg13g2_decap_8
XFILLER_21_143 VPWR VGND sg13g2_decap_8
XFILLER_1_504 VPWR VGND sg13g2_decap_8
XFILLER_49_508 VPWR VGND sg13g2_decap_8
XFILLER_17_449 VPWR VGND sg13g2_decap_8
XFILLER_29_265 VPWR VGND sg13g2_decap_8
XFILLER_12_132 VPWR VGND sg13g2_decap_8
XFILLER_16_95 VPWR VGND sg13g2_decap_8
XFILLER_44_257 VPWR VGND sg13g2_decap_8
XFILLER_9_615 VPWR VGND sg13g2_fill_1
XFILLER_8_125 VPWR VGND sg13g2_decap_8
XFILLER_4_342 VPWR VGND sg13g2_decap_8
XFILLER_0_581 VPWR VGND sg13g2_decap_8
XFILLER_0_592 VPWR VGND sg13g2_fill_2
XFILLER_35_224 VPWR VGND sg13g2_decap_8
XFILLER_36_714 VPWR VGND sg13g2_decap_4
XFILLER_48_574 VPWR VGND sg13g2_decap_8
XFILLER_31_463 VPWR VGND sg13g2_decap_8
XFILLER_43_290 VPWR VGND sg13g2_decap_8
X_0607_ net92 VPWR _0366_ VGND net70 state\[36\] sg13g2_o21ai_1
X_0538_ _0082_ _0313_ _0314_ net43 _0211_ VPWR VGND sg13g2_a22oi_1
XFILLER_27_714 VPWR VGND sg13g2_decap_8
XFILLER_37_28 VPWR VGND sg13g2_decap_8
XFILLER_39_541 VPWR VGND sg13g2_fill_1
XFILLER_39_574 VPWR VGND sg13g2_decap_8
X_0469_ VGND VPWR net33 daisychain\[0\] _0263_ net56 sg13g2_a21oi_1
XFILLER_22_441 VPWR VGND sg13g2_decap_8
XFILLER_26_257 VPWR VGND sg13g2_decap_8
XFILLER_41_216 VPWR VGND sg13g2_decap_8
XFILLER_10_669 VPWR VGND sg13g2_fill_1
XFILLER_1_301 VPWR VGND sg13g2_decap_8
XFILLER_1_378 VPWR VGND sg13g2_decap_8
XFILLER_49_305 VPWR VGND sg13g2_decap_8
XFILLER_17_246 VPWR VGND sg13g2_decap_8
XFILLER_18_714 VPWR VGND sg13g2_decap_8
XFILLER_18_769 VPWR VGND sg13g2_decap_8
XFILLER_45_533 VPWR VGND sg13g2_decap_8
XFILLER_13_430 VPWR VGND sg13g2_decap_8
XFILLER_32_249 VPWR VGND sg13g2_decap_8
XFILLER_40_293 VPWR VGND sg13g2_decap_8
XFILLER_9_445 VPWR VGND sg13g2_decap_8
XFILLER_5_673 VPWR VGND sg13g2_decap_4
XFILLER_4_76 VPWR VGND sg13g2_decap_8
XFILLER_36_511 VPWR VGND sg13g2_decap_8
XFILLER_48_371 VPWR VGND sg13g2_decap_8
XFILLER_23_227 VPWR VGND sg13g2_decap_8
XFILLER_31_260 VPWR VGND sg13g2_decap_8
XFILLER_36_588 VPWR VGND sg13g2_decap_8
XFILLER_2_109 VPWR VGND sg13g2_decap_8
XFILLER_48_49 VPWR VGND sg13g2_decap_8
XFILLER_27_511 VPWR VGND sg13g2_decap_8
XFILLER_27_588 VPWR VGND sg13g2_decap_8
XFILLER_39_371 VPWR VGND sg13g2_decap_8
XFILLER_46_308 VPWR VGND sg13g2_decap_8
XFILLER_10_433 VPWR VGND sg13g2_decap_8
XFILLER_13_41 VPWR VGND sg13g2_decap_8
XFILLER_23_761 VPWR VGND sg13g2_fill_2
XFILLER_42_558 VPWR VGND sg13g2_decap_8
Xfanout31 net32 net31 VPWR VGND sg13g2_buf_1
Xfanout97 net98 net97 VPWR VGND sg13g2_buf_1
Xfanout86 net89 net86 VPWR VGND sg13g2_buf_1
Xfanout75 net76 net75 VPWR VGND sg13g2_buf_1
Xfanout64 net68 net64 VPWR VGND sg13g2_buf_1
Xfanout53 net54 net53 VPWR VGND sg13g2_buf_1
Xfanout42 net45 net42 VPWR VGND sg13g2_buf_1
XFILLER_6_459 VPWR VGND sg13g2_decap_8
XFILLER_1_175 VPWR VGND sg13g2_decap_8
XFILLER_37_308 VPWR VGND sg13g2_decap_8
XFILLER_45_330 VPWR VGND sg13g2_decap_8
XFILLER_49_179 VPWR VGND sg13g2_decap_8
XFILLER_49_102 VPWR VGND sg13g2_decap_8
XFILLER_18_566 VPWR VGND sg13g2_decap_8
XFILLER_33_536 VPWR VGND sg13g2_decap_8
X_0941_ net111 VGND VPWR _0101_ daisychain\[37\] clknet_5_25__leaf_clk sg13g2_dfrbpq_1
XFILLER_13_293 VPWR VGND sg13g2_decap_8
X_0872_ VPWR _0002_ state\[43\] VGND sg13g2_inv_1
XFILLER_9_242 VPWR VGND sg13g2_decap_8
XFILLER_29_809 VPWR VGND sg13g2_decap_8
XFILLER_24_525 VPWR VGND sg13g2_decap_8
XFILLER_34_18 VPWR VGND sg13g2_decap_8
XFILLER_36_385 VPWR VGND sg13g2_decap_8
XFILLER_19_308 VPWR VGND sg13g2_decap_8
XFILLER_46_105 VPWR VGND sg13g2_decap_8
XFILLER_15_569 VPWR VGND sg13g2_decap_8
XFILLER_27_385 VPWR VGND sg13g2_decap_8
XFILLER_30_517 VPWR VGND sg13g2_decap_8
XFILLER_42_322 VPWR VGND sg13g2_decap_8
XFILLER_10_230 VPWR VGND sg13g2_decap_8
XFILLER_23_591 VPWR VGND sg13g2_decap_8
XFILLER_24_84 VPWR VGND sg13g2_decap_8
XFILLER_40_61 VPWR VGND sg13g2_decap_8
XFILLER_42_399 VPWR VGND sg13g2_decap_8
XFILLER_7_702 VPWR VGND sg13g2_decap_4
XFILLER_6_256 VPWR VGND sg13g2_decap_8
XFILLER_27_7 VPWR VGND sg13g2_decap_8
XFILLER_2_473 VPWR VGND sg13g2_decap_8
Xdigitalen0.g\[3\].u.inv1 VPWR digitalen0.g\[3\].u.OUTN net6 VGND sg13g2_inv_1
XFILLER_49_81 VPWR VGND sg13g2_decap_8
XFILLER_18_363 VPWR VGND sg13g2_decap_8
XFILLER_1_77 VPWR VGND sg13g2_decap_8
XFILLER_37_105 VPWR VGND sg13g2_decap_8
XFILLER_21_528 VPWR VGND sg13g2_decap_8
XFILLER_33_333 VPWR VGND sg13g2_decap_8
X_0924_ net109 VGND VPWR _0084_ daisychain\[20\] clknet_5_20__leaf_clk sg13g2_dfrbpq_1
X_0855_ VPWR _0227_ daisychain\[34\] VGND sg13g2_inv_1
X_0786_ VPWR _0032_ state\[0\] VGND sg13g2_inv_1
XFILLER_29_628 VPWR VGND sg13g2_decap_8
XFILLER_24_322 VPWR VGND sg13g2_decap_8
XFILLER_36_182 VPWR VGND sg13g2_decap_8
XFILLER_37_650 VPWR VGND sg13g2_fill_2
XFILLER_43_108 VPWR VGND sg13g2_decap_8
XFILLER_45_28 VPWR VGND sg13g2_decap_4
XFILLER_24_399 VPWR VGND sg13g2_decap_8
XFILLER_10_20 VPWR VGND sg13g2_decap_8
XFILLER_10_97 VPWR VGND sg13g2_decap_8
XFILLER_19_105 VPWR VGND sg13g2_decap_8
XFILLER_19_84 VPWR VGND sg13g2_decap_8
XFILLER_35_609 VPWR VGND sg13g2_decap_8
XFILLER_47_469 VPWR VGND sg13g2_decap_8
XFILLER_15_366 VPWR VGND sg13g2_decap_8
XFILLER_27_182 VPWR VGND sg13g2_decap_8
XFILLER_30_314 VPWR VGND sg13g2_decap_8
XFILLER_31_804 VPWR VGND sg13g2_decap_8
XFILLER_42_152 VPWR VGND sg13g2_decap_8
XFILLER_42_196 VPWR VGND sg13g2_decap_8
XFILLER_11_561 VPWR VGND sg13g2_decap_8
XFILLER_11_583 VPWR VGND sg13g2_decap_8
X_0640_ _0237_ net72 _0390_ _0391_ VPWR VGND sg13g2_a21o_1
X_0571_ net81 VPWR _0339_ VGND net60 state\[27\] sg13g2_o21ai_1
XFILLER_7_598 VPWR VGND sg13g2_decap_8
XFILLER_7_532 VPWR VGND sg13g2_decap_8
XFILLER_25_4 VPWR VGND sg13g2_decap_4
XFILLER_2_270 VPWR VGND sg13g2_decap_8
XFILLER_3_760 VPWR VGND sg13g2_decap_8
XFILLER_3_782 VPWR VGND sg13g2_decap_8
XFILLER_18_160 VPWR VGND sg13g2_decap_8
XFILLER_19_672 VPWR VGND sg13g2_decap_8
XFILLER_33_130 VPWR VGND sg13g2_decap_8
XFILLER_34_620 VPWR VGND sg13g2_decap_8
XFILLER_34_675 VPWR VGND sg13g2_decap_4
XFILLER_34_686 VPWR VGND sg13g2_fill_1
XFILLER_38_469 VPWR VGND sg13g2_decap_8
X_1054_ daisychain\[62\] net22 VPWR VGND sg13g2_buf_1
XFILLER_21_325 VPWR VGND sg13g2_decap_8
X_0907_ net102 VGND VPWR _0067_ daisychain\[3\] clknet_5_8__leaf_clk sg13g2_dfrbpq_1
Xoutput19 net19 uo_out[3] VPWR VGND sg13g2_buf_1
X_0838_ VPWR _0050_ state\[26\] VGND sg13g2_inv_1
X_0769_ _0406_ VPWR _0177_ VGND net97 _0008_ sg13g2_o21ai_1
XFILLER_29_447 VPWR VGND sg13g2_decap_8
XFILLER_44_439 VPWR VGND sg13g2_decap_8
XFILLER_12_314 VPWR VGND sg13g2_decap_8
XFILLER_13_804 VPWR VGND sg13g2_fill_1
XFILLER_24_196 VPWR VGND sg13g2_decap_8
XFILLER_25_620 VPWR VGND sg13g2_decap_8
XFILLER_25_697 VPWR VGND sg13g2_decap_8
XFILLER_40_634 VPWR VGND sg13g2_fill_1
XFILLER_40_667 VPWR VGND sg13g2_decap_4
XFILLER_8_307 VPWR VGND sg13g2_decap_8
XFILLER_21_52 VPWR VGND sg13g2_decap_8
XFILLER_4_524 VPWR VGND sg13g2_decap_8
XFILLER_0_774 VPWR VGND sg13g2_decap_4
XFILLER_16_620 VPWR VGND sg13g2_decap_8
XFILLER_16_675 VPWR VGND sg13g2_fill_2
XFILLER_35_406 VPWR VGND sg13g2_decap_8
XFILLER_47_266 VPWR VGND sg13g2_decap_8
XFILLER_15_163 VPWR VGND sg13g2_decap_8
XFILLER_30_111 VPWR VGND sg13g2_decap_8
XFILLER_30_188 VPWR VGND sg13g2_decap_8
XFILLER_31_645 VPWR VGND sg13g2_fill_1
XFILLER_7_21 VPWR VGND sg13g2_decap_8
XFILLER_3_590 VPWR VGND sg13g2_fill_2
X_0623_ net96 VPWR _0378_ VGND net73 state\[40\] sg13g2_o21ai_1
X_0554_ _0086_ _0325_ _0326_ net42 _0215_ VPWR VGND sg13g2_a22oi_1
XFILLER_7_98 VPWR VGND sg13g2_decap_8
XFILLER_38_266 VPWR VGND sg13g2_decap_8
X_0485_ VGND VPWR net24 daisychain\[4\] _0275_ net39 sg13g2_a21oi_1
XFILLER_21_122 VPWR VGND sg13g2_decap_8
XFILLER_22_623 VPWR VGND sg13g2_decap_8
XFILLER_26_439 VPWR VGND sg13g2_decap_8
XFILLER_34_494 VPWR VGND sg13g2_decap_8
XFILLER_21_199 VPWR VGND sg13g2_decap_8
XFILLER_17_428 VPWR VGND sg13g2_decap_8
XFILLER_29_244 VPWR VGND sg13g2_decap_8
XFILLER_44_236 VPWR VGND sg13g2_decap_8
XFILLER_12_111 VPWR VGND sg13g2_decap_8
XFILLER_12_188 VPWR VGND sg13g2_decap_8
XFILLER_16_74 VPWR VGND sg13g2_decap_8
XFILLER_25_494 VPWR VGND sg13g2_decap_8
XFILLER_8_104 VPWR VGND sg13g2_decap_8
XFILLER_32_95 VPWR VGND sg13g2_decap_8
XFILLER_4_398 VPWR VGND sg13g2_decap_8
XFILLER_4_321 VPWR VGND sg13g2_decap_8
XFILLER_0_560 VPWR VGND sg13g2_decap_8
XFILLER_35_203 VPWR VGND sg13g2_decap_8
XFILLER_48_553 VPWR VGND sg13g2_decap_8
XFILLER_16_494 VPWR VGND sg13g2_decap_8
XFILLER_23_409 VPWR VGND sg13g2_decap_8
XFILLER_31_442 VPWR VGND sg13g2_decap_8
X_0606_ _0099_ _0364_ _0365_ net47 _0228_ VPWR VGND sg13g2_a22oi_1
X_0537_ VGND VPWR net26 daisychain\[17\] _0314_ net43 sg13g2_a21oi_1
XFILLER_26_236 VPWR VGND sg13g2_decap_8
X_0468_ _0194_ net77 _0261_ _0262_ VPWR VGND sg13g2_a21o_1
XFILLER_10_604 VPWR VGND sg13g2_decap_8
XFILLER_22_420 VPWR VGND sg13g2_decap_8
XFILLER_22_497 VPWR VGND sg13g2_decap_8
XFILLER_34_291 VPWR VGND sg13g2_decap_8
Xclkbuf_5_13__f_clk clknet_5_13__leaf_clk clknet_4_6_0_clk VPWR VGND sg13g2_buf_16
XFILLER_1_357 VPWR VGND sg13g2_decap_8
XFILLER_45_512 VPWR VGND sg13g2_decap_8
XFILLER_17_225 VPWR VGND sg13g2_decap_8
XFILLER_27_84 VPWR VGND sg13g2_decap_8
XFILLER_32_228 VPWR VGND sg13g2_decap_8
XFILLER_33_729 VPWR VGND sg13g2_fill_1
XFILLER_45_589 VPWR VGND sg13g2_decap_8
XFILLER_13_486 VPWR VGND sg13g2_decap_8
XFILLER_40_272 VPWR VGND sg13g2_decap_8
XFILLER_43_94 VPWR VGND sg13g2_decap_8
XFILLER_9_424 VPWR VGND sg13g2_decap_8
XFILLER_4_55 VPWR VGND sg13g2_decap_8
XFILLER_4_22 VPWR VGND sg13g2_fill_2
XFILLER_4_195 VPWR VGND sg13g2_decap_8
XFILLER_4_11 VPWR VGND sg13g2_decap_8
XFILLER_24_707 VPWR VGND sg13g2_decap_4
XFILLER_36_567 VPWR VGND sg13g2_decap_8
XFILLER_48_350 VPWR VGND sg13g2_decap_8
XFILLER_16_291 VPWR VGND sg13g2_decap_8
XFILLER_23_206 VPWR VGND sg13g2_decap_8
XFILLER_24_729 VPWR VGND sg13g2_decap_8
XFILLER_39_350 VPWR VGND sg13g2_decap_8
XFILLER_48_28 VPWR VGND sg13g2_decap_8
XFILLER_27_567 VPWR VGND sg13g2_decap_8
XFILLER_42_537 VPWR VGND sg13g2_decap_8
XFILLER_10_412 VPWR VGND sg13g2_decap_8
XFILLER_10_489 VPWR VGND sg13g2_decap_8
XFILLER_13_20 VPWR VGND sg13g2_decap_8
XFILLER_13_97 VPWR VGND sg13g2_decap_8
XFILLER_22_294 VPWR VGND sg13g2_decap_8
Xfanout32 net33 net32 VPWR VGND sg13g2_buf_1
Xfanout98 net4 net98 VPWR VGND sg13g2_buf_1
Xfanout87 net88 net87 VPWR VGND sg13g2_buf_1
Xfanout76 net77 net76 VPWR VGND sg13g2_buf_1
Xfanout65 net68 net65 VPWR VGND sg13g2_buf_1
Xfanout54 net55 net54 VPWR VGND sg13g2_buf_1
Xfanout43 net45 net43 VPWR VGND sg13g2_buf_1
XFILLER_6_438 VPWR VGND sg13g2_decap_8
XFILLER_1_154 VPWR VGND sg13g2_decap_8
XFILLER_2_600 VPWR VGND sg13g2_fill_1
XFILLER_2_666 VPWR VGND sg13g2_decap_8
XFILLER_18_545 VPWR VGND sg13g2_decap_8
XFILLER_49_158 VPWR VGND sg13g2_decap_8
XFILLER_13_272 VPWR VGND sg13g2_decap_8
XFILLER_14_740 VPWR VGND sg13g2_fill_1
XFILLER_33_515 VPWR VGND sg13g2_decap_8
XFILLER_45_386 VPWR VGND sg13g2_decap_8
X_0940_ net112 VGND VPWR _0100_ daisychain\[36\] clknet_5_25__leaf_clk sg13g2_dfrbpq_1
XFILLER_9_221 VPWR VGND sg13g2_decap_8
X_0871_ VPWR _0235_ daisychain\[42\] VGND sg13g2_inv_1
XFILLER_9_298 VPWR VGND sg13g2_decap_8
XFILLER_49_670 VPWR VGND sg13g2_fill_1
XFILLER_24_504 VPWR VGND sg13g2_decap_8
XFILLER_36_364 VPWR VGND sg13g2_decap_8
XFILLER_37_821 VPWR VGND sg13g2_fill_2
XFILLER_49_681 VPWR VGND sg13g2_decap_4
XFILLER_32_592 VPWR VGND sg13g2_decap_8
XFILLER_15_548 VPWR VGND sg13g2_decap_8
XFILLER_23_570 VPWR VGND sg13g2_decap_8
XFILLER_24_63 VPWR VGND sg13g2_decap_8
XFILLER_27_364 VPWR VGND sg13g2_decap_8
XFILLER_42_301 VPWR VGND sg13g2_decap_8
XFILLER_42_378 VPWR VGND sg13g2_decap_8
XFILLER_10_286 VPWR VGND sg13g2_decap_8
XFILLER_6_235 VPWR VGND sg13g2_decap_8
XFILLER_2_452 VPWR VGND sg13g2_decap_8
Xdigitalen0.g\[3\].u.inv2 VPWR digitalen0.g\[3\].u.OUTP digitalen0.g\[3\].u.OUTN VGND
+ sg13g2_inv_1
XFILLER_49_60 VPWR VGND sg13g2_decap_8
XFILLER_18_342 VPWR VGND sg13g2_decap_8
XFILLER_1_56 VPWR VGND sg13g2_decap_8
XFILLER_33_312 VPWR VGND sg13g2_decap_8
XFILLER_45_183 VPWR VGND sg13g2_decap_8
XFILLER_21_507 VPWR VGND sg13g2_decap_8
XFILLER_33_389 VPWR VGND sg13g2_decap_8
X_0923_ net108 VGND VPWR _0083_ daisychain\[19\] clknet_5_20__leaf_clk sg13g2_dfrbpq_1
X_0854_ VPWR _0022_ state\[34\] VGND sg13g2_inv_1
XFILLER_46_0 VPWR VGND sg13g2_decap_8
X_0785_ VPWR _0192_ net80 VGND sg13g2_inv_1
XFILLER_28_139 VPWR VGND sg13g2_decap_8
XFILLER_12_529 VPWR VGND sg13g2_decap_8
XFILLER_24_301 VPWR VGND sg13g2_decap_8
XFILLER_24_378 VPWR VGND sg13g2_decap_8
XFILLER_25_813 VPWR VGND sg13g2_decap_8
XFILLER_36_161 VPWR VGND sg13g2_decap_8
XFILLER_20_584 VPWR VGND sg13g2_decap_8
XFILLER_10_76 VPWR VGND sg13g2_decap_8
XFILLER_3_249 VPWR VGND sg13g2_decap_8
XFILLER_15_345 VPWR VGND sg13g2_decap_8
XFILLER_19_63 VPWR VGND sg13g2_decap_8
XFILLER_27_161 VPWR VGND sg13g2_decap_8
XFILLER_28_684 VPWR VGND sg13g2_decap_8
XFILLER_34_109 VPWR VGND sg13g2_decap_8
XFILLER_47_448 VPWR VGND sg13g2_decap_8
XFILLER_11_540 VPWR VGND sg13g2_decap_8
XFILLER_35_84 VPWR VGND sg13g2_decap_8
XFILLER_42_131 VPWR VGND sg13g2_decap_8
XFILLER_42_175 VPWR VGND sg13g2_decap_8
XFILLER_43_676 VPWR VGND sg13g2_fill_1
XFILLER_7_511 VPWR VGND sg13g2_decap_8
X_0570_ _0090_ _0337_ _0338_ net40 _0219_ VPWR VGND sg13g2_a22oi_1
XFILLER_18_4 VPWR VGND sg13g2_fill_2
XFILLER_19_651 VPWR VGND sg13g2_decap_8
XFILLER_38_448 VPWR VGND sg13g2_decap_8
XFILLER_21_304 VPWR VGND sg13g2_decap_8
XFILLER_33_186 VPWR VGND sg13g2_decap_8
X_1053_ daisychain\[61\] net21 VPWR VGND sg13g2_buf_1
X_0906_ net102 VGND VPWR _0066_ daisychain\[2\] clknet_5_9__leaf_clk sg13g2_dfrbpq_1
X_0837_ VPWR _0218_ daisychain\[25\] VGND sg13g2_inv_1
X_0768_ _0403_ VPWR _0176_ VGND net97 _0007_ sg13g2_o21ai_1
X_0699_ net79 VPWR _0435_ VGND net58 state\[59\] sg13g2_o21ai_1
XFILLER_16_109 VPWR VGND sg13g2_decap_8
XFILLER_29_426 VPWR VGND sg13g2_decap_8
XFILLER_44_418 VPWR VGND sg13g2_decap_8
XFILLER_24_175 VPWR VGND sg13g2_decap_8
XFILLER_25_676 VPWR VGND sg13g2_decap_8
XFILLER_40_613 VPWR VGND sg13g2_decap_8
XFILLER_20_381 VPWR VGND sg13g2_decap_8
XFILLER_21_31 VPWR VGND sg13g2_decap_8
XFILLER_4_503 VPWR VGND sg13g2_decap_8
XFILLER_0_742 VPWR VGND sg13g2_fill_1
XFILLER_0_753 VPWR VGND sg13g2_decap_8
XFILLER_0_786 VPWR VGND sg13g2_decap_8
XFILLER_47_245 VPWR VGND sg13g2_decap_8
XFILLER_15_142 VPWR VGND sg13g2_decap_8
XFILLER_31_624 VPWR VGND sg13g2_decap_8
XFILLER_43_484 VPWR VGND sg13g2_decap_8
XFILLER_30_167 VPWR VGND sg13g2_decap_8
XFILLER_7_77 VPWR VGND sg13g2_decap_8
X_0622_ _0103_ _0376_ _0377_ net52 _0232_ VPWR VGND sg13g2_a22oi_1
X_0553_ VGND VPWR net27 daisychain\[21\] _0326_ net42 sg13g2_a21oi_1
X_0484_ _0198_ net59 _0273_ _0274_ VPWR VGND sg13g2_a21o_1
XFILLER_7_385 VPWR VGND sg13g2_decap_8
XFILLER_26_418 VPWR VGND sg13g2_decap_8
XFILLER_38_245 VPWR VGND sg13g2_decap_8
XFILLER_21_101 VPWR VGND sg13g2_decap_8
XFILLER_21_178 VPWR VGND sg13g2_decap_8
XFILLER_22_602 VPWR VGND sg13g2_decap_8
XFILLER_22_679 VPWR VGND sg13g2_decap_8
XFILLER_34_473 VPWR VGND sg13g2_decap_8
XFILLER_1_539 VPWR VGND sg13g2_decap_8
XFILLER_29_223 VPWR VGND sg13g2_decap_8
XFILLER_16_53 VPWR VGND sg13g2_decap_8
XFILLER_17_407 VPWR VGND sg13g2_decap_8
XFILLER_25_473 VPWR VGND sg13g2_decap_8
XFILLER_44_215 VPWR VGND sg13g2_decap_8
XFILLER_12_167 VPWR VGND sg13g2_decap_8
XFILLER_32_74 VPWR VGND sg13g2_decap_8
XFILLER_40_454 VPWR VGND sg13g2_decap_8
XFILLER_40_465 VPWR VGND sg13g2_fill_1
XFILLER_40_498 VPWR VGND sg13g2_decap_8
XFILLER_4_300 VPWR VGND sg13g2_decap_8
XFILLER_4_377 VPWR VGND sg13g2_decap_8
XFILLER_36_727 VPWR VGND sg13g2_fill_2
XFILLER_48_532 VPWR VGND sg13g2_decap_8
XFILLER_16_473 VPWR VGND sg13g2_decap_8
XFILLER_31_421 VPWR VGND sg13g2_decap_8
XFILLER_35_259 VPWR VGND sg13g2_decap_8
XFILLER_12_690 VPWR VGND sg13g2_fill_1
XFILLER_31_498 VPWR VGND sg13g2_decap_8
XFILLER_7_182 VPWR VGND sg13g2_decap_8
XFILLER_39_532 VPWR VGND sg13g2_decap_8
X_0605_ VGND VPWR net28 daisychain\[34\] _0365_ net49 sg13g2_a21oi_1
X_0536_ _0211_ net65 _0312_ _0313_ VPWR VGND sg13g2_a21o_1
X_0467_ net99 VPWR _0261_ VGND net77 state\[1\] sg13g2_o21ai_1
XFILLER_26_215 VPWR VGND sg13g2_decap_8
XFILLER_34_270 VPWR VGND sg13g2_decap_8
X_1019_ net116 VGND VPWR _0179_ state\[51\] clknet_5_29__leaf_clk sg13g2_dfrbpq_1
XFILLER_22_476 VPWR VGND sg13g2_decap_8
XFILLER_1_336 VPWR VGND sg13g2_decap_8
XFILLER_17_204 VPWR VGND sg13g2_decap_8
XFILLER_27_63 VPWR VGND sg13g2_decap_8
XFILLER_13_465 VPWR VGND sg13g2_decap_8
XFILLER_32_207 VPWR VGND sg13g2_decap_8
XFILLER_40_251 VPWR VGND sg13g2_decap_8
XFILLER_43_73 VPWR VGND sg13g2_decap_8
XFILLER_45_568 VPWR VGND sg13g2_decap_8
XFILLER_9_403 VPWR VGND sg13g2_decap_8
XFILLER_5_631 VPWR VGND sg13g2_decap_8
XFILLER_4_34 VPWR VGND sg13g2_decap_8
XFILLER_4_174 VPWR VGND sg13g2_decap_8
XFILLER_36_546 VPWR VGND sg13g2_decap_8
XFILLER_16_270 VPWR VGND sg13g2_decap_8
XFILLER_31_295 VPWR VGND sg13g2_decap_8
X_0519_ net85 VPWR _0300_ VGND net64 state\[14\] sg13g2_o21ai_1
XFILLER_14_229 VPWR VGND sg13g2_decap_8
XFILLER_27_546 VPWR VGND sg13g2_decap_8
XFILLER_42_516 VPWR VGND sg13g2_decap_8
Xfanout33 _0192_ net33 VPWR VGND sg13g2_buf_1
Xfanout55 net56 net55 VPWR VGND sg13g2_buf_1
Xfanout44 net45 net44 VPWR VGND sg13g2_buf_1
XFILLER_10_468 VPWR VGND sg13g2_decap_8
XFILLER_13_76 VPWR VGND sg13g2_decap_8
XFILLER_22_273 VPWR VGND sg13g2_decap_8
Xfanout99 net4 net99 VPWR VGND sg13g2_buf_1
Xfanout88 net89 net88 VPWR VGND sg13g2_buf_1
Xfanout77 net78 net77 VPWR VGND sg13g2_buf_1
Xfanout66 net67 net66 VPWR VGND sg13g2_buf_1
XFILLER_6_417 VPWR VGND sg13g2_decap_8
XFILLER_1_133 VPWR VGND sg13g2_decap_8
XFILLER_49_137 VPWR VGND sg13g2_decap_8
XFILLER_18_524 VPWR VGND sg13g2_decap_8
XFILLER_38_84 VPWR VGND sg13g2_decap_8
XFILLER_45_365 VPWR VGND sg13g2_decap_8
XFILLER_13_251 VPWR VGND sg13g2_decap_8
XFILLER_41_571 VPWR VGND sg13g2_decap_8
X_0870_ VPWR _0001_ state\[42\] VGND sg13g2_inv_1
XFILLER_9_277 VPWR VGND sg13g2_decap_8
XFILLER_9_200 VPWR VGND sg13g2_decap_8
XFILLER_5_494 VPWR VGND sg13g2_decap_8
XFILLER_36_343 VPWR VGND sg13g2_decap_8
XFILLER_32_571 VPWR VGND sg13g2_decap_8
X_0999_ net109 VGND VPWR _0159_ state\[31\] clknet_5_3__leaf_clk sg13g2_dfrbpq_1
XFILLER_15_527 VPWR VGND sg13g2_decap_8
XFILLER_27_343 VPWR VGND sg13g2_decap_8
XFILLER_28_822 VPWR VGND sg13g2_fill_1
XFILLER_24_42 VPWR VGND sg13g2_decap_8
XFILLER_42_357 VPWR VGND sg13g2_decap_8
XFILLER_10_265 VPWR VGND sg13g2_decap_8
XFILLER_2_431 VPWR VGND sg13g2_decap_8
XFILLER_40_96 VPWR VGND sg13g2_decap_8
XFILLER_6_214 VPWR VGND sg13g2_decap_8
XFILLER_19_822 VPWR VGND sg13g2_fill_1
XFILLER_1_35 VPWR VGND sg13g2_decap_8
XFILLER_18_321 VPWR VGND sg13g2_decap_8
XFILLER_18_398 VPWR VGND sg13g2_decap_8
XFILLER_33_368 VPWR VGND sg13g2_decap_8
XFILLER_45_162 VPWR VGND sg13g2_decap_8
XFILLER_46_696 VPWR VGND sg13g2_decap_4
XFILLER_14_593 VPWR VGND sg13g2_decap_8
X_0922_ net108 VGND VPWR _0082_ daisychain\[18\] clknet_5_1__leaf_clk sg13g2_dfrbpq_1
X_0853_ VPWR _0226_ daisychain\[33\] VGND sg13g2_inv_1
XFILLER_39_0 VPWR VGND sg13g2_decap_4
X_0784_ _0449_ VPWR _0191_ VGND net79 _0024_ sg13g2_o21ai_1
XFILLER_5_291 VPWR VGND sg13g2_decap_8
XFILLER_28_118 VPWR VGND sg13g2_decap_8
XFILLER_36_140 VPWR VGND sg13g2_decap_8
XFILLER_37_674 VPWR VGND sg13g2_fill_2
Xinput1 rst_n net1 VPWR VGND sg13g2_buf_1
XFILLER_12_508 VPWR VGND sg13g2_decap_8
XFILLER_24_357 VPWR VGND sg13g2_decap_8
XFILLER_10_55 VPWR VGND sg13g2_decap_8
XFILLER_20_563 VPWR VGND sg13g2_decap_8
XFILLER_3_228 VPWR VGND sg13g2_decap_8
XFILLER_19_42 VPWR VGND sg13g2_decap_8
XFILLER_47_427 VPWR VGND sg13g2_decap_8
XFILLER_15_324 VPWR VGND sg13g2_decap_8
XFILLER_27_140 VPWR VGND sg13g2_decap_8
XFILLER_35_63 VPWR VGND sg13g2_decap_8
XFILLER_42_110 VPWR VGND sg13g2_decap_8
XFILLER_30_349 VPWR VGND sg13g2_decap_8
XFILLER_19_630 VPWR VGND sg13g2_decap_8
XFILLER_38_427 VPWR VGND sg13g2_decap_8
X_1052_ daisychain\[60\] net20 VPWR VGND sg13g2_buf_1
XFILLER_14_390 VPWR VGND sg13g2_decap_8
XFILLER_18_195 VPWR VGND sg13g2_decap_8
XFILLER_33_165 VPWR VGND sg13g2_decap_8
XFILLER_34_655 VPWR VGND sg13g2_decap_8
X_0905_ net102 VGND VPWR _0065_ daisychain\[1\] clknet_5_11__leaf_clk sg13g2_dfrbpq_1
X_0836_ VPWR _0049_ state\[25\] VGND sg13g2_inv_1
X_0767_ _0400_ VPWR _0175_ VGND net97 _0006_ sg13g2_o21ai_1
XFILLER_29_405 VPWR VGND sg13g2_decap_8
X_0698_ _0122_ _0433_ _0434_ net36 _0251_ VPWR VGND sg13g2_a22oi_1
XFILLER_13_817 VPWR VGND sg13g2_decap_4
XFILLER_25_655 VPWR VGND sg13g2_decap_8
XFILLER_12_349 VPWR VGND sg13g2_decap_8
XFILLER_20_360 VPWR VGND sg13g2_decap_8
XFILLER_24_154 VPWR VGND sg13g2_decap_8
XFILLER_21_87 VPWR VGND sg13g2_decap_8
XFILLER_0_798 VPWR VGND sg13g2_fill_1
XFILLER_47_224 VPWR VGND sg13g2_decap_8
XFILLER_15_121 VPWR VGND sg13g2_decap_8
XFILLER_15_198 VPWR VGND sg13g2_decap_8
XFILLER_16_655 VPWR VGND sg13g2_decap_8
XFILLER_16_688 VPWR VGND sg13g2_fill_1
XFILLER_28_482 VPWR VGND sg13g2_decap_8
XFILLER_30_146 VPWR VGND sg13g2_decap_8
XFILLER_31_603 VPWR VGND sg13g2_decap_8
XFILLER_43_430 VPWR VGND sg13g2_decap_8
XFILLER_46_84 VPWR VGND sg13g2_decap_8
Xclkbuf_5_0__f_clk clknet_5_0__leaf_clk clknet_4_0_0_clk VPWR VGND sg13g2_buf_16
XFILLER_11_382 VPWR VGND sg13g2_decap_8
X_0621_ VGND VPWR net29 daisychain\[38\] _0377_ net52 sg13g2_a21oi_1
XFILLER_7_56 VPWR VGND sg13g2_decap_8
XFILLER_7_364 VPWR VGND sg13g2_decap_8
X_0552_ _0215_ net67 _0324_ _0325_ VPWR VGND sg13g2_a21o_1
X_0483_ net81 VPWR _0273_ VGND net59 state\[5\] sg13g2_o21ai_1
XFILLER_34_452 VPWR VGND sg13g2_decap_8
XFILLER_38_224 VPWR VGND sg13g2_decap_8
XFILLER_21_157 VPWR VGND sg13g2_decap_8
XFILLER_22_658 VPWR VGND sg13g2_decap_8
XFILLER_1_518 VPWR VGND sg13g2_decap_8
X_0819_ VPWR _0209_ daisychain\[16\] VGND sg13g2_inv_1
XFILLER_29_202 VPWR VGND sg13g2_decap_8
XFILLER_29_279 VPWR VGND sg13g2_decap_8
XFILLER_16_32 VPWR VGND sg13g2_decap_8
XFILLER_25_452 VPWR VGND sg13g2_decap_8
XFILLER_40_433 VPWR VGND sg13g2_decap_8
XFILLER_12_146 VPWR VGND sg13g2_decap_8
XFILLER_32_53 VPWR VGND sg13g2_decap_8
XFILLER_8_139 VPWR VGND sg13g2_decap_8
XFILLER_4_356 VPWR VGND sg13g2_decap_8
XFILLER_48_511 VPWR VGND sg13g2_decap_8
XFILLER_35_238 VPWR VGND sg13g2_decap_8
XFILLER_48_588 VPWR VGND sg13g2_decap_8
XFILLER_16_452 VPWR VGND sg13g2_decap_8
XFILLER_31_400 VPWR VGND sg13g2_decap_8
XFILLER_31_477 VPWR VGND sg13g2_decap_8
X_0604_ _0228_ net69 _0363_ _0364_ VPWR VGND sg13g2_a21o_1
XFILLER_8_662 VPWR VGND sg13g2_fill_1
XFILLER_7_161 VPWR VGND sg13g2_decap_8
XFILLER_39_511 VPWR VGND sg13g2_decap_8
X_0535_ net86 VPWR _0312_ VGND net65 state\[18\] sg13g2_o21ai_1
X_0466_ _0064_ _0260_ _0258_ net37 _0193_ VPWR VGND sg13g2_a22oi_1
XFILLER_27_728 VPWR VGND sg13g2_decap_8
XFILLER_27_739 VPWR VGND sg13g2_fill_2
XFILLER_35_750 VPWR VGND sg13g2_decap_4
XFILLER_39_588 VPWR VGND sg13g2_decap_8
X_1018_ net116 VGND VPWR _0178_ state\[50\] clknet_5_31__leaf_clk sg13g2_dfrbpq_1
XFILLER_10_617 VPWR VGND sg13g2_fill_1
XFILLER_22_455 VPWR VGND sg13g2_decap_8
XFILLER_5_109 VPWR VGND sg13g2_decap_8
XFILLER_1_315 VPWR VGND sg13g2_decap_8
XFILLER_49_319 VPWR VGND sg13g2_decap_8
XFILLER_18_706 VPWR VGND sg13g2_decap_4
XFILLER_27_42 VPWR VGND sg13g2_decap_8
XFILLER_45_547 VPWR VGND sg13g2_decap_8
XFILLER_13_444 VPWR VGND sg13g2_decap_8
XFILLER_25_293 VPWR VGND sg13g2_decap_8
XFILLER_26_761 VPWR VGND sg13g2_fill_2
XFILLER_40_230 VPWR VGND sg13g2_decap_8
XFILLER_9_459 VPWR VGND sg13g2_decap_8
XFILLER_4_153 VPWR VGND sg13g2_decap_8
XFILLER_0_392 VPWR VGND sg13g2_decap_8
XFILLER_36_525 VPWR VGND sg13g2_decap_8
XFILLER_48_385 VPWR VGND sg13g2_decap_8
XFILLER_31_274 VPWR VGND sg13g2_decap_8
X_0518_ _0077_ _0298_ _0299_ net41 _0206_ VPWR VGND sg13g2_a22oi_1
XFILLER_27_525 VPWR VGND sg13g2_decap_8
XFILLER_39_385 VPWR VGND sg13g2_decap_8
XFILLER_14_208 VPWR VGND sg13g2_decap_8
XFILLER_22_252 VPWR VGND sg13g2_decap_8
Xfanout34 _0192_ net34 VPWR VGND sg13g2_buf_1
Xfanout89 net98 net89 VPWR VGND sg13g2_buf_1
Xfanout78 net5 net78 VPWR VGND sg13g2_buf_1
Xfanout67 net68 net67 VPWR VGND sg13g2_buf_1
Xfanout56 _0259_ net56 VPWR VGND sg13g2_buf_1
Xfanout45 net46 net45 VPWR VGND sg13g2_buf_1
XFILLER_10_447 VPWR VGND sg13g2_decap_8
XFILLER_13_55 VPWR VGND sg13g2_decap_8
XFILLER_1_112 VPWR VGND sg13g2_decap_8
XFILLER_1_189 VPWR VGND sg13g2_decap_8
XFILLER_38_63 VPWR VGND sg13g2_decap_8
XFILLER_8_4 VPWR VGND sg13g2_decap_4
XFILLER_49_116 VPWR VGND sg13g2_decap_8
XFILLER_18_503 VPWR VGND sg13g2_decap_8
XFILLER_45_344 VPWR VGND sg13g2_decap_8
XFILLER_13_230 VPWR VGND sg13g2_decap_8
XFILLER_14_775 VPWR VGND sg13g2_fill_1
XFILLER_41_550 VPWR VGND sg13g2_decap_8
XFILLER_9_256 VPWR VGND sg13g2_decap_8
XFILLER_5_473 VPWR VGND sg13g2_decap_8
XFILLER_36_322 VPWR VGND sg13g2_decap_8
XFILLER_48_182 VPWR VGND sg13g2_decap_8
XFILLER_49_661 VPWR VGND sg13g2_decap_8
XFILLER_24_539 VPWR VGND sg13g2_decap_8
XFILLER_32_550 VPWR VGND sg13g2_decap_8
XFILLER_36_399 VPWR VGND sg13g2_decap_8
X_0998_ net109 VGND VPWR _0158_ state\[30\] clknet_5_2__leaf_clk sg13g2_dfrbpq_1
XFILLER_47_609 VPWR VGND sg13g2_decap_8
XFILLER_15_506 VPWR VGND sg13g2_decap_8
XFILLER_27_322 VPWR VGND sg13g2_decap_8
XFILLER_27_399 VPWR VGND sg13g2_decap_8
XFILLER_39_182 VPWR VGND sg13g2_decap_8
XFILLER_42_336 VPWR VGND sg13g2_decap_8
XFILLER_46_119 VPWR VGND sg13g2_decap_8
XFILLER_10_244 VPWR VGND sg13g2_decap_8
XFILLER_24_98 VPWR VGND sg13g2_decap_8
XFILLER_2_410 VPWR VGND sg13g2_decap_8
XFILLER_40_75 VPWR VGND sg13g2_decap_8
XFILLER_18_300 VPWR VGND sg13g2_decap_8
XFILLER_1_14 VPWR VGND sg13g2_decap_8
XFILLER_2_487 VPWR VGND sg13g2_decap_8
XFILLER_37_119 VPWR VGND sg13g2_decap_8
XFILLER_38_609 VPWR VGND sg13g2_decap_8
XFILLER_46_631 VPWR VGND sg13g2_decap_8
XFILLER_49_95 VPWR VGND sg13g2_decap_8
XFILLER_14_572 VPWR VGND sg13g2_decap_8
XFILLER_18_377 VPWR VGND sg13g2_decap_8
XFILLER_33_347 VPWR VGND sg13g2_decap_8
XFILLER_34_804 VPWR VGND sg13g2_decap_8
XFILLER_45_141 VPWR VGND sg13g2_decap_8
X_0921_ net108 VGND VPWR _0081_ daisychain\[17\] clknet_5_0__leaf_clk sg13g2_dfrbpq_1
XFILLER_41_391 VPWR VGND sg13g2_decap_8
X_0852_ VPWR _0011_ state\[33\] VGND sg13g2_inv_1
X_0783_ _0451_ VPWR _0190_ VGND _0444_ _0445_ sg13g2_o21ai_1
XFILLER_5_270 VPWR VGND sg13g2_decap_8
XFILLER_24_336 VPWR VGND sg13g2_decap_8
XFILLER_36_196 VPWR VGND sg13g2_decap_8
Xinput2 ui_in[0] net2 VPWR VGND sg13g2_buf_1
XFILLER_49_480 VPWR VGND sg13g2_decap_8
XFILLER_20_542 VPWR VGND sg13g2_decap_8
XFILLER_10_34 VPWR VGND sg13g2_decap_8
XFILLER_3_207 VPWR VGND sg13g2_decap_8
XFILLER_19_119 VPWR VGND sg13g2_decap_8
XFILLER_19_98 VPWR VGND sg13g2_decap_8
XFILLER_47_406 VPWR VGND sg13g2_decap_8
XFILLER_15_303 VPWR VGND sg13g2_decap_8
XFILLER_27_196 VPWR VGND sg13g2_decap_8
XFILLER_30_328 VPWR VGND sg13g2_decap_8
XFILLER_31_818 VPWR VGND sg13g2_decap_4
XFILLER_35_42 VPWR VGND sg13g2_decap_8
XFILLER_43_612 VPWR VGND sg13g2_fill_2
XFILLER_11_575 VPWR VGND sg13g2_decap_4
XFILLER_11_597 VPWR VGND sg13g2_decap_8
Xclkbuf_5_19__f_clk clknet_5_19__leaf_clk clknet_4_9_0_clk VPWR VGND sg13g2_buf_16
XFILLER_7_546 VPWR VGND sg13g2_decap_8
XFILLER_2_284 VPWR VGND sg13g2_decap_8
XFILLER_3_774 VPWR VGND sg13g2_fill_2
XFILLER_18_174 VPWR VGND sg13g2_decap_8
XFILLER_18_6 VPWR VGND sg13g2_fill_1
XFILLER_34_634 VPWR VGND sg13g2_decap_8
XFILLER_38_406 VPWR VGND sg13g2_decap_8
XFILLER_46_483 VPWR VGND sg13g2_decap_8
X_1051_ daisychain\[59\] net19 VPWR VGND sg13g2_buf_1
XFILLER_21_339 VPWR VGND sg13g2_decap_8
XFILLER_33_144 VPWR VGND sg13g2_decap_8
X_0904_ net102 VGND VPWR _0064_ daisychain\[0\] clknet_5_19__leaf_clk sg13g2_dfrbpq_1
X_0835_ VPWR _0217_ daisychain\[24\] VGND sg13g2_inv_1
X_0766_ _0397_ VPWR _0174_ VGND net95 _0005_ sg13g2_o21ai_1
X_0697_ VGND VPWR net34 daisychain\[57\] _0434_ net36 sg13g2_a21oi_1
XFILLER_24_133 VPWR VGND sg13g2_decap_8
XFILLER_25_634 VPWR VGND sg13g2_decap_8
XFILLER_37_483 VPWR VGND sg13g2_decap_8
XFILLER_12_328 VPWR VGND sg13g2_decap_8
XFILLER_0_711 VPWR VGND sg13g2_fill_2
XFILLER_0_733 VPWR VGND sg13g2_decap_8
XFILLER_21_66 VPWR VGND sg13g2_decap_8
XFILLER_4_538 VPWR VGND sg13g2_decap_4
XFILLER_15_100 VPWR VGND sg13g2_decap_8
XFILLER_16_634 VPWR VGND sg13g2_decap_8
XFILLER_28_461 VPWR VGND sg13g2_decap_8
XFILLER_46_63 VPWR VGND sg13g2_decap_8
XFILLER_47_203 VPWR VGND sg13g2_decap_8
XFILLER_15_177 VPWR VGND sg13g2_decap_8
XFILLER_30_125 VPWR VGND sg13g2_decap_8
XFILLER_11_361 VPWR VGND sg13g2_decap_8
X_0620_ _0232_ net74 _0375_ _0376_ VPWR VGND sg13g2_a21o_1
X_0551_ net88 VPWR _0324_ VGND net67 state\[22\] sg13g2_o21ai_1
XFILLER_7_35 VPWR VGND sg13g2_decap_8
XFILLER_7_343 VPWR VGND sg13g2_decap_8
XFILLER_23_4 VPWR VGND sg13g2_decap_8
XFILLER_38_203 VPWR VGND sg13g2_decap_8
X_0482_ _0068_ _0271_ _0272_ net37 _0197_ VPWR VGND sg13g2_a22oi_1
XFILLER_19_483 VPWR VGND sg13g2_decap_8
XFILLER_34_431 VPWR VGND sg13g2_decap_8
XFILLER_46_280 VPWR VGND sg13g2_decap_8
XFILLER_21_136 VPWR VGND sg13g2_decap_8
XFILLER_22_637 VPWR VGND sg13g2_decap_8
XFILLER_30_692 VPWR VGND sg13g2_decap_8
X_0818_ VPWR _0039_ state\[16\] VGND sg13g2_inv_1
X_0749_ _0346_ VPWR _0157_ VGND net83 _0053_ sg13g2_o21ai_1
XFILLER_29_258 VPWR VGND sg13g2_decap_8
XFILLER_12_125 VPWR VGND sg13g2_decap_8
XFILLER_16_22 VPWR VGND sg13g2_fill_1
XFILLER_16_88 VPWR VGND sg13g2_decap_8
XFILLER_37_280 VPWR VGND sg13g2_decap_8
XFILLER_40_412 VPWR VGND sg13g2_decap_8
XFILLER_8_118 VPWR VGND sg13g2_decap_8
XFILLER_32_32 VPWR VGND sg13g2_decap_8
XFILLER_4_335 VPWR VGND sg13g2_decap_8
XFILLER_0_574 VPWR VGND sg13g2_decap_8
XFILLER_16_431 VPWR VGND sg13g2_decap_8
XFILLER_35_217 VPWR VGND sg13g2_decap_8
XFILLER_36_707 VPWR VGND sg13g2_decap_8
XFILLER_48_567 VPWR VGND sg13g2_decap_8
XFILLER_31_456 VPWR VGND sg13g2_decap_8
XFILLER_43_283 VPWR VGND sg13g2_decap_8
XFILLER_7_140 VPWR VGND sg13g2_decap_8
X_0603_ net90 VPWR _0363_ VGND net69 state\[35\] sg13g2_o21ai_1
X_0534_ _0081_ _0310_ _0311_ net43 _0210_ VPWR VGND sg13g2_a22oi_1
XFILLER_27_707 VPWR VGND sg13g2_decap_8
XFILLER_39_567 VPWR VGND sg13g2_decap_8
X_0465_ VGND VPWR net33 net2 _0260_ net37 sg13g2_a21oi_1
XFILLER_19_280 VPWR VGND sg13g2_decap_8
XFILLER_22_434 VPWR VGND sg13g2_decap_8
XFILLER_41_209 VPWR VGND sg13g2_decap_8
X_1017_ net117 VGND VPWR _0177_ state\[49\] clknet_5_31__leaf_clk sg13g2_dfrbpq_1
XFILLER_17_239 VPWR VGND sg13g2_decap_8
XFILLER_26_740 VPWR VGND sg13g2_decap_8
XFILLER_27_21 VPWR VGND sg13g2_decap_8
XFILLER_27_98 VPWR VGND sg13g2_decap_8
XFILLER_45_526 VPWR VGND sg13g2_decap_8
XFILLER_13_423 VPWR VGND sg13g2_decap_8
XFILLER_25_272 VPWR VGND sg13g2_decap_8
XFILLER_40_286 VPWR VGND sg13g2_decap_8
XFILLER_9_438 VPWR VGND sg13g2_decap_8
XFILLER_5_677 VPWR VGND sg13g2_fill_1
XFILLER_4_132 VPWR VGND sg13g2_decap_8
XFILLER_0_371 VPWR VGND sg13g2_decap_8
XFILLER_36_504 VPWR VGND sg13g2_decap_8
XFILLER_4_69 VPWR VGND sg13g2_decap_8
XFILLER_49_821 VPWR VGND sg13g2_fill_2
XFILLER_49_810 VPWR VGND sg13g2_decap_8
XFILLER_48_364 VPWR VGND sg13g2_decap_8
XFILLER_31_253 VPWR VGND sg13g2_decap_8
XFILLER_32_776 VPWR VGND sg13g2_decap_4
XFILLER_44_581 VPWR VGND sg13g2_decap_8
XFILLER_8_482 VPWR VGND sg13g2_decap_8
X_0517_ VGND VPWR net27 daisychain\[12\] _0299_ net41 sg13g2_a21oi_1
XFILLER_27_504 VPWR VGND sg13g2_decap_8
XFILLER_39_364 VPWR VGND sg13g2_decap_8
XFILLER_10_426 VPWR VGND sg13g2_decap_8
XFILLER_13_34 VPWR VGND sg13g2_decap_8
XFILLER_22_231 VPWR VGND sg13g2_decap_8
XFILLER_23_732 VPWR VGND sg13g2_fill_2
XFILLER_35_581 VPWR VGND sg13g2_decap_8
Xfanout24 net25 net24 VPWR VGND sg13g2_buf_1
Xfanout35 _0259_ net35 VPWR VGND sg13g2_buf_1
Xfanout79 net80 net79 VPWR VGND sg13g2_buf_1
Xfanout68 net78 net68 VPWR VGND sg13g2_buf_1
Xfanout57 net78 net57 VPWR VGND sg13g2_buf_1
Xfanout46 net55 net46 VPWR VGND sg13g2_buf_1
XFILLER_1_168 VPWR VGND sg13g2_decap_8
XFILLER_38_42 VPWR VGND sg13g2_decap_8
XFILLER_18_559 VPWR VGND sg13g2_decap_8
XFILLER_33_529 VPWR VGND sg13g2_decap_8
XFILLER_45_323 VPWR VGND sg13g2_decap_8
XFILLER_13_286 VPWR VGND sg13g2_decap_8
XFILLER_9_235 VPWR VGND sg13g2_decap_8
XFILLER_5_452 VPWR VGND sg13g2_decap_8
XFILLER_24_518 VPWR VGND sg13g2_decap_8
XFILLER_36_301 VPWR VGND sg13g2_decap_8
XFILLER_36_378 VPWR VGND sg13g2_decap_8
XFILLER_48_161 VPWR VGND sg13g2_decap_8
XFILLER_49_640 VPWR VGND sg13g2_decap_8
X_0997_ net118 VGND VPWR _0157_ state\[29\] clknet_5_6__leaf_clk sg13g2_dfrbpq_1
XFILLER_27_301 VPWR VGND sg13g2_decap_8
XFILLER_39_161 VPWR VGND sg13g2_decap_4
XFILLER_27_378 VPWR VGND sg13g2_decap_8
XFILLER_42_315 VPWR VGND sg13g2_decap_8
XFILLER_10_223 VPWR VGND sg13g2_decap_8
XFILLER_23_584 VPWR VGND sg13g2_decap_8
XFILLER_24_77 VPWR VGND sg13g2_decap_8
XFILLER_40_54 VPWR VGND sg13g2_decap_8
XFILLER_7_706 VPWR VGND sg13g2_fill_2
XFILLER_6_249 VPWR VGND sg13g2_decap_8
XFILLER_2_466 VPWR VGND sg13g2_decap_8
XFILLER_18_356 VPWR VGND sg13g2_decap_8
XFILLER_45_120 VPWR VGND sg13g2_decap_8
XFILLER_49_74 VPWR VGND sg13g2_decap_8
XFILLER_14_551 VPWR VGND sg13g2_decap_8
XFILLER_33_326 VPWR VGND sg13g2_decap_8
XFILLER_41_370 VPWR VGND sg13g2_decap_8
XFILLER_45_197 VPWR VGND sg13g2_decap_8
X_0920_ net108 VGND VPWR _0080_ daisychain\[16\] clknet_5_0__leaf_clk sg13g2_dfrbpq_1
X_0851_ VPWR _0225_ daisychain\[32\] VGND sg13g2_inv_1
X_0782_ _0451_ net34 state\[62\] VPWR VGND sg13g2_nand2_1
XFILLER_24_315 VPWR VGND sg13g2_decap_8
XFILLER_36_175 VPWR VGND sg13g2_decap_8
Xinput3 ui_in[1] net3 VPWR VGND sg13g2_buf_1
XFILLER_20_521 VPWR VGND sg13g2_decap_8
XFILLER_20_598 VPWR VGND sg13g2_decap_8
XFILLER_10_13 VPWR VGND sg13g2_decap_8
XFILLER_19_77 VPWR VGND sg13g2_decap_8
XFILLER_28_643 VPWR VGND sg13g2_fill_2
XFILLER_15_359 VPWR VGND sg13g2_decap_8
XFILLER_23_381 VPWR VGND sg13g2_decap_8
XFILLER_27_175 VPWR VGND sg13g2_decap_8
XFILLER_28_698 VPWR VGND sg13g2_decap_8
XFILLER_30_307 VPWR VGND sg13g2_decap_8
XFILLER_35_21 VPWR VGND sg13g2_decap_8
XFILLER_35_98 VPWR VGND sg13g2_decap_8
XFILLER_42_145 VPWR VGND sg13g2_decap_8
XFILLER_42_189 VPWR VGND sg13g2_decap_8
XFILLER_43_668 VPWR VGND sg13g2_decap_4
XFILLER_11_554 VPWR VGND sg13g2_decap_8
XFILLER_7_525 VPWR VGND sg13g2_decap_8
XFILLER_25_8 VPWR VGND sg13g2_fill_1
XFILLER_2_263 VPWR VGND sg13g2_decap_8
XFILLER_18_153 VPWR VGND sg13g2_decap_8
XFILLER_19_665 VPWR VGND sg13g2_decap_8
XFILLER_33_123 VPWR VGND sg13g2_decap_8
XFILLER_34_613 VPWR VGND sg13g2_decap_8
XFILLER_46_462 VPWR VGND sg13g2_decap_8
X_1050_ daisychain\[58\] net18 VPWR VGND sg13g2_buf_1
XFILLER_21_318 VPWR VGND sg13g2_decap_8
X_0903_ VPWR _0251_ daisychain\[58\] VGND sg13g2_inv_1
X_0834_ VPWR _0048_ state\[24\] VGND sg13g2_inv_1
XFILLER_44_0 VPWR VGND sg13g2_decap_8
X_0765_ _0394_ VPWR _0173_ VGND net94 _0004_ sg13g2_o21ai_1
X_0696_ _0251_ net58 _0432_ _0433_ VPWR VGND sg13g2_a21o_1
XFILLER_6_580 VPWR VGND sg13g2_decap_8
Xclkbuf_5_25__f_clk clknet_5_25__leaf_clk clknet_4_12_0_clk VPWR VGND sg13g2_buf_16
XFILLER_12_307 VPWR VGND sg13g2_decap_8
XFILLER_13_808 VPWR VGND sg13g2_decap_4
XFILLER_24_112 VPWR VGND sg13g2_decap_8
XFILLER_24_189 VPWR VGND sg13g2_decap_8
XFILLER_25_613 VPWR VGND sg13g2_decap_8
XFILLER_37_462 VPWR VGND sg13g2_decap_8
XFILLER_40_627 VPWR VGND sg13g2_decap_8
XFILLER_20_395 VPWR VGND sg13g2_decap_8
XFILLER_21_45 VPWR VGND sg13g2_decap_8
XFILLER_4_517 VPWR VGND sg13g2_decap_8
XFILLER_0_767 VPWR VGND sg13g2_decap_8
XFILLER_16_613 VPWR VGND sg13g2_decap_8
XFILLER_28_440 VPWR VGND sg13g2_decap_8
XFILLER_46_42 VPWR VGND sg13g2_decap_8
XFILLER_47_259 VPWR VGND sg13g2_decap_8
XFILLER_11_340 VPWR VGND sg13g2_decap_8
XFILLER_15_156 VPWR VGND sg13g2_decap_8
XFILLER_30_104 VPWR VGND sg13g2_decap_8
XFILLER_31_638 VPWR VGND sg13g2_decap_8
XFILLER_43_498 VPWR VGND sg13g2_decap_8
XFILLER_7_322 VPWR VGND sg13g2_decap_8
XFILLER_7_14 VPWR VGND sg13g2_decap_8
XFILLER_3_550 VPWR VGND sg13g2_decap_8
X_0550_ _0085_ _0322_ _0323_ net44 _0214_ VPWR VGND sg13g2_a22oi_1
XFILLER_7_399 VPWR VGND sg13g2_decap_8
XFILLER_16_4 VPWR VGND sg13g2_decap_4
XFILLER_38_259 VPWR VGND sg13g2_decap_8
X_0481_ VGND VPWR net33 daisychain\[3\] _0272_ net37 sg13g2_a21oi_1
XFILLER_19_462 VPWR VGND sg13g2_decap_8
XFILLER_21_115 VPWR VGND sg13g2_decap_8
XFILLER_22_616 VPWR VGND sg13g2_decap_8
XFILLER_34_410 VPWR VGND sg13g2_decap_8
XFILLER_34_487 VPWR VGND sg13g2_decap_8
XFILLER_30_671 VPWR VGND sg13g2_decap_8
X_0817_ VPWR _0208_ daisychain\[15\] VGND sg13g2_inv_1
X_0748_ _0343_ VPWR _0156_ VGND net83 _0052_ sg13g2_o21ai_1
X_0679_ net91 VPWR _0420_ VGND net69 state\[54\] sg13g2_o21ai_1
XFILLER_29_237 VPWR VGND sg13g2_decap_8
XFILLER_44_229 VPWR VGND sg13g2_decap_8
XFILLER_12_104 VPWR VGND sg13g2_decap_8
XFILLER_13_605 VPWR VGND sg13g2_decap_8
XFILLER_16_67 VPWR VGND sg13g2_decap_8
XFILLER_21_682 VPWR VGND sg13g2_decap_8
XFILLER_25_487 VPWR VGND sg13g2_decap_8
XFILLER_32_11 VPWR VGND sg13g2_decap_4
XFILLER_20_192 VPWR VGND sg13g2_decap_8
XFILLER_32_88 VPWR VGND sg13g2_decap_8
XFILLER_4_314 VPWR VGND sg13g2_decap_8
XFILLER_0_553 VPWR VGND sg13g2_decap_8
XFILLER_48_546 VPWR VGND sg13g2_decap_8
XFILLER_16_410 VPWR VGND sg13g2_decap_8
XFILLER_16_487 VPWR VGND sg13g2_decap_8
XFILLER_31_435 VPWR VGND sg13g2_decap_8
XFILLER_43_262 VPWR VGND sg13g2_decap_8
X_0602_ _0098_ _0361_ _0362_ net49 _0227_ VPWR VGND sg13g2_a22oi_1
X_0533_ VGND VPWR net26 daisychain\[16\] _0311_ net43 sg13g2_a21oi_1
X_0464_ net79 net3 _0259_ VPWR VGND sg13g2_nor2_1
XFILLER_7_196 VPWR VGND sg13g2_decap_8
XFILLER_26_229 VPWR VGND sg13g2_decap_8
XFILLER_22_413 VPWR VGND sg13g2_decap_8
XFILLER_34_284 VPWR VGND sg13g2_decap_8
X_1016_ net117 VGND VPWR _0176_ state\[48\] clknet_5_31__leaf_clk sg13g2_dfrbpq_1
Xheichips25_pudding_120 VPWR VGND uio_oe[1] sg13g2_tiehi
XFILLER_8_90 VPWR VGND sg13g2_decap_8
XFILLER_17_218 VPWR VGND sg13g2_decap_8
XFILLER_25_251 VPWR VGND sg13g2_decap_8
XFILLER_27_77 VPWR VGND sg13g2_decap_8
XFILLER_43_21 VPWR VGND sg13g2_decap_8
XFILLER_45_505 VPWR VGND sg13g2_decap_8
XFILLER_13_479 VPWR VGND sg13g2_decap_8
XFILLER_40_265 VPWR VGND sg13g2_decap_8
XFILLER_43_87 VPWR VGND sg13g2_decap_8
XFILLER_9_417 VPWR VGND sg13g2_decap_8
XFILLER_4_48 VPWR VGND sg13g2_decap_8
XFILLER_4_188 VPWR VGND sg13g2_decap_8
XFILLER_4_111 VPWR VGND sg13g2_decap_8
XFILLER_0_350 VPWR VGND sg13g2_decap_8
XFILLER_17_741 VPWR VGND sg13g2_fill_1
XFILLER_48_343 VPWR VGND sg13g2_decap_8
XFILLER_16_284 VPWR VGND sg13g2_decap_8
XFILLER_31_232 VPWR VGND sg13g2_decap_8
XFILLER_32_700 VPWR VGND sg13g2_fill_1
XFILLER_44_560 VPWR VGND sg13g2_decap_8
XFILLER_8_461 VPWR VGND sg13g2_decap_8
XFILLER_39_343 VPWR VGND sg13g2_decap_8
X_0516_ _0206_ net63 _0297_ _0298_ VPWR VGND sg13g2_a21o_1
XFILLER_22_210 VPWR VGND sg13g2_decap_8
XFILLER_35_560 VPWR VGND sg13g2_decap_8
XFILLER_10_405 VPWR VGND sg13g2_decap_8
XFILLER_13_13 VPWR VGND sg13g2_decap_8
XFILLER_22_287 VPWR VGND sg13g2_decap_8
Xfanout25 net32 net25 VPWR VGND sg13g2_buf_1
Xfanout69 net71 net69 VPWR VGND sg13g2_buf_1
Xfanout58 net78 net58 VPWR VGND sg13g2_buf_1
Xfanout47 net48 net47 VPWR VGND sg13g2_buf_1
Xfanout36 _0259_ net36 VPWR VGND sg13g2_buf_1
XFILLER_1_147 VPWR VGND sg13g2_decap_8
XFILLER_2_659 VPWR VGND sg13g2_decap_8
XFILLER_18_538 VPWR VGND sg13g2_decap_8
XFILLER_38_21 VPWR VGND sg13g2_decap_8
XFILLER_38_98 VPWR VGND sg13g2_decap_8
XFILLER_45_302 VPWR VGND sg13g2_decap_8
XFILLER_13_265 VPWR VGND sg13g2_decap_8
XFILLER_26_593 VPWR VGND sg13g2_decap_8
XFILLER_33_508 VPWR VGND sg13g2_decap_8
XFILLER_45_379 VPWR VGND sg13g2_decap_8
XFILLER_9_214 VPWR VGND sg13g2_decap_8
XFILLER_5_431 VPWR VGND sg13g2_decap_8
Xclkbuf_5_6__f_clk clknet_5_6__leaf_clk clknet_4_3_0_clk VPWR VGND sg13g2_buf_16
XFILLER_48_7 VPWR VGND sg13g2_decap_8
XFILLER_17_582 VPWR VGND sg13g2_decap_8
XFILLER_36_357 VPWR VGND sg13g2_decap_8
XFILLER_48_140 VPWR VGND sg13g2_decap_8
XFILLER_32_585 VPWR VGND sg13g2_decap_8
XFILLER_44_390 VPWR VGND sg13g2_decap_8
X_0996_ net106 VGND VPWR _0156_ state\[28\] clknet_5_14__leaf_clk sg13g2_dfrbpq_1
XFILLER_39_140 VPWR VGND sg13g2_decap_8
XFILLER_23_563 VPWR VGND sg13g2_decap_8
XFILLER_24_56 VPWR VGND sg13g2_decap_8
XFILLER_27_357 VPWR VGND sg13g2_decap_8
XFILLER_10_202 VPWR VGND sg13g2_decap_8
XFILLER_10_279 VPWR VGND sg13g2_decap_8
XFILLER_6_228 VPWR VGND sg13g2_decap_8
XFILLER_2_445 VPWR VGND sg13g2_decap_8
XFILLER_49_53 VPWR VGND sg13g2_decap_8
XFILLER_18_335 VPWR VGND sg13g2_decap_8
XFILLER_1_49 VPWR VGND sg13g2_decap_8
XFILLER_33_305 VPWR VGND sg13g2_decap_8
XFILLER_45_176 VPWR VGND sg13g2_decap_8
XFILLER_46_677 VPWR VGND sg13g2_fill_2
XFILLER_14_530 VPWR VGND sg13g2_decap_8
XFILLER_26_390 VPWR VGND sg13g2_decap_8
X_0850_ VPWR _0000_ state\[32\] VGND sg13g2_inv_1
X_0781_ _0442_ VPWR _0189_ VGND net80 _0021_ sg13g2_o21ai_1
Xinput4 ui_in[2] net4 VPWR VGND sg13g2_buf_1
XFILLER_20_500 VPWR VGND sg13g2_decap_8
XFILLER_25_806 VPWR VGND sg13g2_decap_8
XFILLER_36_154 VPWR VGND sg13g2_decap_8
XFILLER_20_577 VPWR VGND sg13g2_decap_8
XFILLER_32_382 VPWR VGND sg13g2_decap_8
X_0979_ net104 VGND VPWR _0139_ state\[11\] clknet_5_4__leaf_clk sg13g2_dfrbpq_1
XFILLER_10_69 VPWR VGND sg13g2_decap_8
XFILLER_19_56 VPWR VGND sg13g2_decap_8
XFILLER_27_154 VPWR VGND sg13g2_decap_8
XFILLER_28_622 VPWR VGND sg13g2_decap_8
XFILLER_28_677 VPWR VGND sg13g2_decap_8
XFILLER_11_533 VPWR VGND sg13g2_decap_8
XFILLER_15_338 VPWR VGND sg13g2_decap_8
XFILLER_23_360 VPWR VGND sg13g2_decap_8
XFILLER_35_77 VPWR VGND sg13g2_decap_8
XFILLER_42_124 VPWR VGND sg13g2_decap_8
XFILLER_42_168 VPWR VGND sg13g2_decap_8
XFILLER_7_504 VPWR VGND sg13g2_decap_8
XFILLER_2_242 VPWR VGND sg13g2_decap_8
XFILLER_18_132 VPWR VGND sg13g2_decap_8
XFILLER_19_644 VPWR VGND sg13g2_decap_8
XFILLER_33_102 VPWR VGND sg13g2_decap_8
XFILLER_33_179 VPWR VGND sg13g2_decap_8
XFILLER_34_669 VPWR VGND sg13g2_fill_2
XFILLER_46_441 VPWR VGND sg13g2_decap_8
X_0902_ VPWR _0018_ state\[58\] VGND sg13g2_inv_1
X_0833_ VPWR _0216_ daisychain\[23\] VGND sg13g2_inv_1
XFILLER_37_0 VPWR VGND sg13g2_decap_8
X_0764_ _0391_ VPWR _0172_ VGND net94 _0003_ sg13g2_o21ai_1
X_0695_ net79 VPWR _0432_ VGND net58 state\[58\] sg13g2_o21ai_1
XFILLER_29_419 VPWR VGND sg13g2_decap_8
XFILLER_2_81 VPWR VGND sg13g2_decap_8
XFILLER_37_441 VPWR VGND sg13g2_decap_8
XFILLER_24_168 VPWR VGND sg13g2_decap_8
XFILLER_25_669 VPWR VGND sg13g2_decap_8
XFILLER_20_374 VPWR VGND sg13g2_decap_8
XFILLER_0_713 VPWR VGND sg13g2_fill_1
XFILLER_0_746 VPWR VGND sg13g2_decap_8
XFILLER_15_135 VPWR VGND sg13g2_decap_8
XFILLER_28_496 VPWR VGND sg13g2_decap_8
XFILLER_31_617 VPWR VGND sg13g2_decap_8
XFILLER_43_477 VPWR VGND sg13g2_decap_8
XFILLER_46_21 VPWR VGND sg13g2_decap_8
XFILLER_46_98 VPWR VGND sg13g2_decap_8
XFILLER_47_238 VPWR VGND sg13g2_decap_8
XFILLER_11_396 VPWR VGND sg13g2_decap_8
XFILLER_7_301 VPWR VGND sg13g2_decap_8
XFILLER_3_595 VPWR VGND sg13g2_decap_8
Xclkbuf_5_31__f_clk clknet_5_31__leaf_clk clknet_4_15_0_clk VPWR VGND sg13g2_buf_16
X_0480_ _0197_ net59 _0270_ _0271_ VPWR VGND sg13g2_a21o_1
XFILLER_7_378 VPWR VGND sg13g2_decap_8
XFILLER_19_441 VPWR VGND sg13g2_decap_8
XFILLER_38_238 VPWR VGND sg13g2_decap_8
XFILLER_39_706 VPWR VGND sg13g2_decap_4
XFILLER_30_650 VPWR VGND sg13g2_decap_8
XFILLER_34_466 VPWR VGND sg13g2_decap_8
XFILLER_47_794 VPWR VGND sg13g2_fill_2
X_0816_ VPWR _0038_ state\[15\] VGND sg13g2_inv_1
X_0747_ _0340_ VPWR _0155_ VGND net82 _0051_ sg13g2_o21ai_1
XFILLER_29_216 VPWR VGND sg13g2_decap_8
X_0678_ _0117_ _0418_ _0419_ net47 _0246_ VPWR VGND sg13g2_a22oi_1
XFILLER_16_46 VPWR VGND sg13g2_decap_8
XFILLER_25_466 VPWR VGND sg13g2_decap_8
XFILLER_44_208 VPWR VGND sg13g2_decap_8
XFILLER_20_171 VPWR VGND sg13g2_decap_8
XFILLER_21_661 VPWR VGND sg13g2_decap_8
XFILLER_32_67 VPWR VGND sg13g2_decap_8
XFILLER_40_447 VPWR VGND sg13g2_decap_8
XFILLER_0_532 VPWR VGND sg13g2_decap_8
XFILLER_48_525 VPWR VGND sg13g2_decap_8
XFILLER_16_466 VPWR VGND sg13g2_decap_8
XFILLER_28_293 VPWR VGND sg13g2_decap_8
XFILLER_31_414 VPWR VGND sg13g2_decap_8
XFILLER_43_241 VPWR VGND sg13g2_decap_8
XFILLER_44_731 VPWR VGND sg13g2_fill_1
XFILLER_11_193 VPWR VGND sg13g2_decap_8
XFILLER_12_694 VPWR VGND sg13g2_fill_2
X_0601_ VGND VPWR net28 daisychain\[33\] _0362_ net49 sg13g2_a21oi_1
XFILLER_7_175 VPWR VGND sg13g2_decap_8
XFILLER_39_525 VPWR VGND sg13g2_decap_8
X_0532_ _0210_ net65 _0309_ _0310_ VPWR VGND sg13g2_a21o_1
X_0463_ net59 _0193_ _0257_ _0258_ VPWR VGND sg13g2_a21o_1
XFILLER_26_208 VPWR VGND sg13g2_decap_8
X_1015_ net116 VGND VPWR _0175_ state\[47\] clknet_5_23__leaf_clk sg13g2_dfrbpq_1
Xheichips25_pudding_121 VPWR VGND uio_oe[2] sg13g2_tiehi
XFILLER_22_469 VPWR VGND sg13g2_decap_8
XFILLER_34_263 VPWR VGND sg13g2_decap_8
XFILLER_1_329 VPWR VGND sg13g2_decap_8
XFILLER_13_458 VPWR VGND sg13g2_decap_8
XFILLER_25_230 VPWR VGND sg13g2_decap_8
XFILLER_27_56 VPWR VGND sg13g2_decap_8
XFILLER_40_244 VPWR VGND sg13g2_decap_8
XFILLER_43_66 VPWR VGND sg13g2_decap_8
XFILLER_5_624 VPWR VGND sg13g2_decap_8
XFILLER_5_613 VPWR VGND sg13g2_fill_1
XFILLER_4_27 VPWR VGND sg13g2_decap_8
XFILLER_4_167 VPWR VGND sg13g2_decap_8
XFILLER_36_539 VPWR VGND sg13g2_decap_8
XFILLER_48_399 VPWR VGND sg13g2_decap_8
XFILLER_48_322 VPWR VGND sg13g2_decap_8
XFILLER_12_480 VPWR VGND sg13g2_decap_8
XFILLER_16_263 VPWR VGND sg13g2_decap_8
XFILLER_31_211 VPWR VGND sg13g2_decap_8
XFILLER_31_288 VPWR VGND sg13g2_decap_8
XFILLER_8_440 VPWR VGND sg13g2_decap_8
XFILLER_39_322 VPWR VGND sg13g2_decap_8
X_0515_ net84 VPWR _0297_ VGND net63 state\[13\] sg13g2_o21ai_1
XFILLER_27_539 VPWR VGND sg13g2_decap_8
XFILLER_39_399 VPWR VGND sg13g2_decap_8
Xfanout26 net27 net26 VPWR VGND sg13g2_buf_1
Xfanout37 net56 net37 VPWR VGND sg13g2_buf_1
XFILLER_13_69 VPWR VGND sg13g2_decap_8
XFILLER_22_266 VPWR VGND sg13g2_decap_8
Xfanout59 net60 net59 VPWR VGND sg13g2_buf_1
Xfanout48 net49 net48 VPWR VGND sg13g2_buf_1
XFILLER_1_126 VPWR VGND sg13g2_decap_8
XFILLER_18_517 VPWR VGND sg13g2_decap_8
XFILLER_38_77 VPWR VGND sg13g2_decap_8
XFILLER_45_358 VPWR VGND sg13g2_decap_8
XFILLER_13_244 VPWR VGND sg13g2_decap_8
XFILLER_26_572 VPWR VGND sg13g2_decap_8
XFILLER_41_564 VPWR VGND sg13g2_decap_8
XFILLER_5_487 VPWR VGND sg13g2_decap_8
XFILLER_5_410 VPWR VGND sg13g2_decap_8
XFILLER_49_620 VPWR VGND sg13g2_decap_8
XFILLER_17_561 VPWR VGND sg13g2_decap_8
XFILLER_36_336 VPWR VGND sg13g2_decap_8
XFILLER_48_196 VPWR VGND sg13g2_decap_8
XFILLER_32_564 VPWR VGND sg13g2_decap_8
X_0995_ net105 VGND VPWR _0155_ state\[27\] clknet_5_8__leaf_clk sg13g2_dfrbpq_1
XFILLER_5_81 VPWR VGND sg13g2_decap_8
XFILLER_27_336 VPWR VGND sg13g2_decap_8
XFILLER_39_196 VPWR VGND sg13g2_decap_8
XFILLER_11_737 VPWR VGND sg13g2_fill_2
XFILLER_23_542 VPWR VGND sg13g2_decap_8
XFILLER_24_35 VPWR VGND sg13g2_decap_8
XFILLER_10_258 VPWR VGND sg13g2_decap_8
XFILLER_40_89 VPWR VGND sg13g2_decap_8
XFILLER_6_207 VPWR VGND sg13g2_decap_8
XFILLER_1_28 VPWR VGND sg13g2_decap_8
XFILLER_2_424 VPWR VGND sg13g2_decap_8
XFILLER_6_4 VPWR VGND sg13g2_decap_8
XFILLER_49_32 VPWR VGND sg13g2_decap_8
XFILLER_18_314 VPWR VGND sg13g2_decap_8
XFILLER_34_818 VPWR VGND sg13g2_decap_4
XFILLER_45_155 VPWR VGND sg13g2_decap_8
XFILLER_14_586 VPWR VGND sg13g2_decap_8
X_0780_ _0439_ VPWR _0188_ VGND net79 _0020_ sg13g2_o21ai_1
XFILLER_39_4 VPWR VGND sg13g2_fill_1
XFILLER_5_284 VPWR VGND sg13g2_decap_8
XFILLER_1_490 VPWR VGND sg13g2_decap_8
XFILLER_36_133 VPWR VGND sg13g2_decap_8
Xinput5 ui_in[3] net5 VPWR VGND sg13g2_buf_1
XFILLER_49_494 VPWR VGND sg13g2_decap_8
XFILLER_32_361 VPWR VGND sg13g2_decap_8
XFILLER_20_556 VPWR VGND sg13g2_decap_8
X_0978_ net107 VGND VPWR _0138_ state\[10\] clknet_5_6__leaf_clk sg13g2_dfrbpq_1
XFILLER_10_48 VPWR VGND sg13g2_decap_8
XFILLER_19_35 VPWR VGND sg13g2_decap_8
XFILLER_15_317 VPWR VGND sg13g2_decap_8
XFILLER_27_133 VPWR VGND sg13g2_decap_8
XFILLER_28_601 VPWR VGND sg13g2_decap_8
XFILLER_35_56 VPWR VGND sg13g2_decap_8
XFILLER_42_103 VPWR VGND sg13g2_decap_8
XFILLER_11_512 VPWR VGND sg13g2_decap_8
XFILLER_2_221 VPWR VGND sg13g2_decap_8
XFILLER_18_111 VPWR VGND sg13g2_decap_8
XFILLER_19_623 VPWR VGND sg13g2_decap_8
XFILLER_2_298 VPWR VGND sg13g2_decap_8
XFILLER_46_420 VPWR VGND sg13g2_decap_8
XFILLER_14_383 VPWR VGND sg13g2_decap_8
XFILLER_18_188 VPWR VGND sg13g2_decap_8
XFILLER_30_821 VPWR VGND sg13g2_fill_2
XFILLER_33_158 VPWR VGND sg13g2_decap_8
XFILLER_34_648 VPWR VGND sg13g2_decap_8
XFILLER_46_497 VPWR VGND sg13g2_decap_8
X_0901_ VPWR _0250_ daisychain\[57\] VGND sg13g2_inv_1
X_0832_ VPWR _0047_ state\[23\] VGND sg13g2_inv_1
X_0763_ _0388_ VPWR _0171_ VGND net94 _0002_ sg13g2_o21ai_1
X_0694_ _0121_ _0430_ _0431_ net35 _0250_ VPWR VGND sg13g2_a22oi_1
XFILLER_25_648 VPWR VGND sg13g2_decap_8
XFILLER_2_60 VPWR VGND sg13g2_decap_8
XFILLER_37_420 VPWR VGND sg13g2_decap_8
XFILLER_37_497 VPWR VGND sg13g2_decap_8
XFILLER_49_291 VPWR VGND sg13g2_decap_8
XFILLER_20_353 VPWR VGND sg13g2_decap_8
XFILLER_24_147 VPWR VGND sg13g2_decap_8
XFILLER_47_217 VPWR VGND sg13g2_decap_8
XFILLER_15_114 VPWR VGND sg13g2_decap_8
XFILLER_16_648 VPWR VGND sg13g2_decap_8
XFILLER_28_475 VPWR VGND sg13g2_decap_8
XFILLER_43_423 VPWR VGND sg13g2_decap_8
XFILLER_46_77 VPWR VGND sg13g2_decap_8
XFILLER_11_375 VPWR VGND sg13g2_decap_8
XFILLER_30_139 VPWR VGND sg13g2_decap_8
XFILLER_7_49 VPWR VGND sg13g2_decap_8
XFILLER_7_357 VPWR VGND sg13g2_decap_8
XFILLER_3_574 VPWR VGND sg13g2_decap_4
Xclkbuf_4_9_0_clk clknet_0_clk clknet_4_9_0_clk VPWR VGND sg13g2_buf_8
XFILLER_19_420 VPWR VGND sg13g2_decap_8
XFILLER_19_497 VPWR VGND sg13g2_decap_8
XFILLER_38_217 VPWR VGND sg13g2_decap_8
XFILLER_46_294 VPWR VGND sg13g2_decap_8
X_1031_ net101 VGND VPWR _0191_ state\[63\] clknet_5_26__leaf_clk sg13g2_dfrbpq_1
XFILLER_14_180 VPWR VGND sg13g2_decap_8
XFILLER_15_670 VPWR VGND sg13g2_decap_8
XFILLER_34_445 VPWR VGND sg13g2_decap_8
X_0815_ VPWR _0207_ daisychain\[14\] VGND sg13g2_inv_1
X_0746_ _0337_ VPWR _0154_ VGND net82 _0050_ sg13g2_o21ai_1
X_0677_ VGND VPWR net28 daisychain\[52\] _0419_ net47 sg13g2_a21oi_1
XFILLER_25_412 VPWR VGND sg13g2_fill_1
XFILLER_25_445 VPWR VGND sg13g2_decap_8
XFILLER_37_294 VPWR VGND sg13g2_decap_8
XFILLER_40_426 VPWR VGND sg13g2_decap_8
XFILLER_12_139 VPWR VGND sg13g2_decap_8
XFILLER_20_150 VPWR VGND sg13g2_decap_8
XFILLER_21_640 VPWR VGND sg13g2_decap_8
XFILLER_32_46 VPWR VGND sg13g2_decap_8
XFILLER_0_511 VPWR VGND sg13g2_decap_8
XFILLER_4_349 VPWR VGND sg13g2_decap_8
XFILLER_0_588 VPWR VGND sg13g2_decap_4
XFILLER_28_272 VPWR VGND sg13g2_decap_8
XFILLER_48_504 VPWR VGND sg13g2_decap_8
XFILLER_16_445 VPWR VGND sg13g2_decap_8
XFILLER_43_220 VPWR VGND sg13g2_decap_8
XFILLER_43_297 VPWR VGND sg13g2_decap_8
XFILLER_11_172 VPWR VGND sg13g2_decap_8
X_0600_ _0227_ net71 _0360_ _0361_ VPWR VGND sg13g2_a21o_1
X_0531_ net86 VPWR _0309_ VGND net65 state\[17\] sg13g2_o21ai_1
XFILLER_7_154 VPWR VGND sg13g2_decap_8
XFILLER_39_504 VPWR VGND sg13g2_decap_8
XFILLER_3_382 VPWR VGND sg13g2_decap_8
X_0462_ net81 VPWR _0257_ VGND state\[0\] net59 sg13g2_o21ai_1
XFILLER_19_294 VPWR VGND sg13g2_decap_8
XFILLER_34_242 VPWR VGND sg13g2_decap_8
XFILLER_47_581 VPWR VGND sg13g2_decap_8
X_1014_ net115 VGND VPWR _0174_ state\[46\] clknet_5_23__leaf_clk sg13g2_dfrbpq_1
Xheichips25_pudding_122 VPWR VGND uio_oe[3] sg13g2_tiehi
XFILLER_22_448 VPWR VGND sg13g2_decap_8
XFILLER_1_308 VPWR VGND sg13g2_decap_8
X_0729_ _0286_ VPWR _0137_ VGND net85 _0063_ sg13g2_o21ai_1
XFILLER_27_35 VPWR VGND sg13g2_decap_8
XFILLER_38_581 VPWR VGND sg13g2_decap_8
XFILLER_13_437 VPWR VGND sg13g2_decap_8
XFILLER_25_286 VPWR VGND sg13g2_decap_8
XFILLER_26_754 VPWR VGND sg13g2_decap_8
XFILLER_40_223 VPWR VGND sg13g2_decap_8
XFILLER_5_647 VPWR VGND sg13g2_fill_1
XFILLER_5_603 VPWR VGND sg13g2_fill_2
XFILLER_4_146 VPWR VGND sg13g2_decap_8
XFILLER_0_385 VPWR VGND sg13g2_decap_8
XFILLER_48_301 VPWR VGND sg13g2_decap_8
XFILLER_16_242 VPWR VGND sg13g2_decap_8
XFILLER_36_518 VPWR VGND sg13g2_decap_8
XFILLER_48_378 VPWR VGND sg13g2_decap_8
XFILLER_31_267 VPWR VGND sg13g2_decap_8
XFILLER_32_735 VPWR VGND sg13g2_fill_2
X_0514_ _0076_ _0295_ _0296_ net41 _0205_ VPWR VGND sg13g2_a22oi_1
XFILLER_8_496 VPWR VGND sg13g2_decap_8
XFILLER_27_518 VPWR VGND sg13g2_decap_8
XFILLER_39_301 VPWR VGND sg13g2_decap_8
XFILLER_39_378 VPWR VGND sg13g2_decap_8
XFILLER_22_245 VPWR VGND sg13g2_decap_8
XFILLER_35_595 VPWR VGND sg13g2_decap_8
Xfanout27 net32 net27 VPWR VGND sg13g2_buf_1
Xfanout49 net55 net49 VPWR VGND sg13g2_buf_1
Xfanout38 net39 net38 VPWR VGND sg13g2_buf_1
XFILLER_13_48 VPWR VGND sg13g2_decap_8
XFILLER_1_105 VPWR VGND sg13g2_decap_8
XFILLER_8_8 VPWR VGND sg13g2_fill_1
XFILLER_49_109 VPWR VGND sg13g2_decap_8
XFILLER_26_551 VPWR VGND sg13g2_decap_8
XFILLER_38_56 VPWR VGND sg13g2_decap_8
XFILLER_45_337 VPWR VGND sg13g2_decap_8
XFILLER_13_223 VPWR VGND sg13g2_decap_8
XFILLER_14_768 VPWR VGND sg13g2_decap_8
XFILLER_41_543 VPWR VGND sg13g2_decap_8
XFILLER_9_249 VPWR VGND sg13g2_decap_8
XFILLER_5_466 VPWR VGND sg13g2_decap_8
XFILLER_0_182 VPWR VGND sg13g2_decap_8
XFILLER_36_315 VPWR VGND sg13g2_decap_8
XFILLER_48_175 VPWR VGND sg13g2_decap_8
XFILLER_49_654 VPWR VGND sg13g2_decap_8
XFILLER_17_540 VPWR VGND sg13g2_decap_8
XFILLER_32_543 VPWR VGND sg13g2_decap_8
X_0994_ net105 VGND VPWR _0154_ state\[26\] clknet_5_8__leaf_clk sg13g2_dfrbpq_1
XFILLER_8_293 VPWR VGND sg13g2_decap_8
XFILLER_5_60 VPWR VGND sg13g2_decap_8
XFILLER_27_315 VPWR VGND sg13g2_decap_8
XFILLER_39_175 VPWR VGND sg13g2_decap_8
XFILLER_10_237 VPWR VGND sg13g2_decap_8
XFILLER_23_521 VPWR VGND sg13g2_decap_8
XFILLER_23_598 VPWR VGND sg13g2_decap_8
XFILLER_35_392 VPWR VGND sg13g2_decap_8
XFILLER_42_329 VPWR VGND sg13g2_decap_8
XFILLER_2_403 VPWR VGND sg13g2_decap_8
XFILLER_40_68 VPWR VGND sg13g2_decap_8
XFILLER_49_11 VPWR VGND sg13g2_decap_8
XFILLER_46_602 VPWR VGND sg13g2_decap_8
XFILLER_49_88 VPWR VGND sg13g2_decap_8
XFILLER_14_565 VPWR VGND sg13g2_decap_8
XFILLER_45_134 VPWR VGND sg13g2_decap_8
XFILLER_46_679 VPWR VGND sg13g2_fill_1
XFILLER_41_384 VPWR VGND sg13g2_decap_8
XFILLER_30_90 VPWR VGND sg13g2_decap_8
Xclkbuf_5_14__f_clk clknet_5_14__leaf_clk clknet_4_7_0_clk VPWR VGND sg13g2_buf_16
Xwires dac0/VcascP[0] dac0/VcascP[1] dac0/Iout wires/VDDA[0] wires/VDDA[1] dac0/VbiasP[1]
+ dac0/VbiasP[0] dac1/VcascP[0] dac1/VcascP[1] dac1/Iout wires/VDDA[2] wires/VDDA[3]
+ dac1/VbiasP[1] dac1/VbiasP[0] i_in i_out analog_wires
XFILLER_5_263 VPWR VGND sg13g2_decap_8
XFILLER_36_112 VPWR VGND sg13g2_decap_8
XFILLER_37_602 VPWR VGND sg13g2_decap_8
Xinput6 ui_in[4] net6 VPWR VGND sg13g2_buf_1
XFILLER_49_473 VPWR VGND sg13g2_decap_8
XFILLER_20_535 VPWR VGND sg13g2_decap_8
XFILLER_24_329 VPWR VGND sg13g2_decap_8
XFILLER_32_340 VPWR VGND sg13g2_decap_8
XFILLER_36_189 VPWR VGND sg13g2_decap_8
XFILLER_10_27 VPWR VGND sg13g2_decap_8
X_0977_ net107 VGND VPWR _0137_ state\[9\] clknet_5_5__leaf_clk sg13g2_dfrbpq_1
XFILLER_27_112 VPWR VGND sg13g2_decap_8
XFILLER_27_189 VPWR VGND sg13g2_decap_8
XFILLER_35_35 VPWR VGND sg13g2_decap_8
XFILLER_42_159 VPWR VGND sg13g2_decap_4
XFILLER_11_568 VPWR VGND sg13g2_decap_8
XFILLER_23_395 VPWR VGND sg13g2_decap_8
XFILLER_7_539 VPWR VGND sg13g2_decap_8
XFILLER_2_200 VPWR VGND sg13g2_decap_8
XFILLER_2_277 VPWR VGND sg13g2_decap_8
XFILLER_3_767 VPWR VGND sg13g2_decap_8
XFILLER_18_167 VPWR VGND sg13g2_decap_8
XFILLER_19_602 VPWR VGND sg13g2_decap_8
XFILLER_19_679 VPWR VGND sg13g2_fill_2
XFILLER_46_476 VPWR VGND sg13g2_decap_8
XFILLER_14_362 VPWR VGND sg13g2_decap_8
XFILLER_25_90 VPWR VGND sg13g2_decap_8
XFILLER_33_137 VPWR VGND sg13g2_decap_8
XFILLER_34_627 VPWR VGND sg13g2_decap_8
XFILLER_41_181 VPWR VGND sg13g2_decap_8
X_0900_ VPWR _0017_ state\[57\] VGND sg13g2_inv_1
XFILLER_10_590 VPWR VGND sg13g2_decap_8
X_0831_ VPWR _0215_ daisychain\[22\] VGND sg13g2_inv_1
X_0762_ _0385_ VPWR _0170_ VGND net95 _0001_ sg13g2_o21ai_1
X_0693_ VGND VPWR net34 daisychain\[56\] _0431_ net35 sg13g2_a21oi_1
XFILLER_6_594 VPWR VGND sg13g2_fill_1
XFILLER_6_550 VPWR VGND sg13g2_fill_2
XFILLER_24_126 VPWR VGND sg13g2_decap_8
XFILLER_25_627 VPWR VGND sg13g2_decap_8
XFILLER_37_476 VPWR VGND sg13g2_decap_8
XFILLER_49_270 VPWR VGND sg13g2_decap_8
XFILLER_20_332 VPWR VGND sg13g2_decap_8
XFILLER_21_811 VPWR VGND sg13g2_decap_8
XFILLER_21_822 VPWR VGND sg13g2_fill_1
XFILLER_0_704 VPWR VGND sg13g2_decap_8
XFILLER_0_726 VPWR VGND sg13g2_fill_1
XFILLER_21_59 VPWR VGND sg13g2_decap_8
XFILLER_28_454 VPWR VGND sg13g2_decap_8
XFILLER_46_56 VPWR VGND sg13g2_decap_8
XFILLER_16_627 VPWR VGND sg13g2_decap_8
XFILLER_23_192 VPWR VGND sg13g2_decap_8
XFILLER_24_693 VPWR VGND sg13g2_decap_8
XFILLER_30_118 VPWR VGND sg13g2_decap_8
XFILLER_43_402 VPWR VGND sg13g2_decap_8
XFILLER_11_354 VPWR VGND sg13g2_decap_8
XFILLER_7_336 VPWR VGND sg13g2_decap_8
XFILLER_7_28 VPWR VGND sg13g2_decap_8
XFILLER_11_81 VPWR VGND sg13g2_decap_8
XFILLER_3_564 VPWR VGND sg13g2_fill_1
XFILLER_19_476 VPWR VGND sg13g2_decap_8
XFILLER_34_424 VPWR VGND sg13g2_decap_8
XFILLER_46_273 VPWR VGND sg13g2_decap_8
X_1030_ net100 VGND VPWR _0190_ state\[62\] clknet_5_11__leaf_clk sg13g2_dfrbpq_1
XFILLER_21_129 VPWR VGND sg13g2_decap_8
XFILLER_30_685 VPWR VGND sg13g2_decap_8
X_0814_ VPWR _0037_ state\[14\] VGND sg13g2_inv_1
XFILLER_42_0 VPWR VGND sg13g2_decap_8
X_0745_ _0334_ VPWR _0153_ VGND net83 _0049_ sg13g2_o21ai_1
X_0676_ _0246_ net70 _0417_ _0418_ VPWR VGND sg13g2_a21o_1
XFILLER_12_118 VPWR VGND sg13g2_decap_8
XFILLER_37_273 VPWR VGND sg13g2_decap_8
XFILLER_40_405 VPWR VGND sg13g2_decap_8
XFILLER_21_696 VPWR VGND sg13g2_decap_8
XFILLER_32_25 VPWR VGND sg13g2_decap_8
XFILLER_4_328 VPWR VGND sg13g2_decap_8
XFILLER_0_567 VPWR VGND sg13g2_decap_8
XFILLER_16_424 VPWR VGND sg13g2_decap_8
XFILLER_28_251 VPWR VGND sg13g2_decap_8
XFILLER_11_151 VPWR VGND sg13g2_decap_8
XFILLER_24_490 VPWR VGND sg13g2_decap_8
XFILLER_31_449 VPWR VGND sg13g2_decap_8
XFILLER_43_276 VPWR VGND sg13g2_decap_8
XFILLER_8_601 VPWR VGND sg13g2_fill_2
XFILLER_22_91 VPWR VGND sg13g2_decap_8
XFILLER_3_361 VPWR VGND sg13g2_decap_8
X_0530_ _0080_ _0307_ _0308_ net43 _0209_ VPWR VGND sg13g2_a22oi_1
XFILLER_7_133 VPWR VGND sg13g2_decap_8
X_0461_ VPWR _0256_ daisychain\[63\] VGND sg13g2_inv_1
XFILLER_19_273 VPWR VGND sg13g2_decap_8
XFILLER_22_427 VPWR VGND sg13g2_decap_8
XFILLER_34_221 VPWR VGND sg13g2_decap_8
XFILLER_34_298 VPWR VGND sg13g2_decap_8
XFILLER_47_560 VPWR VGND sg13g2_decap_8
X_1013_ net117 VGND VPWR _0173_ state\[45\] clknet_5_23__leaf_clk sg13g2_dfrbpq_1
Xheichips25_pudding_123 VPWR VGND uio_oe[4] sg13g2_tiehi
XFILLER_30_482 VPWR VGND sg13g2_decap_8
X_0728_ _0283_ VPWR _0136_ VGND net83 _0062_ sg13g2_o21ai_1
X_0659_ net97 VPWR _0405_ VGND net75 state\[49\] sg13g2_o21ai_1
XFILLER_26_733 VPWR VGND sg13g2_decap_8
XFILLER_27_14 VPWR VGND sg13g2_decap_8
XFILLER_38_560 VPWR VGND sg13g2_decap_8
XFILLER_45_519 VPWR VGND sg13g2_decap_8
XFILLER_13_416 VPWR VGND sg13g2_decap_8
XFILLER_25_265 VPWR VGND sg13g2_decap_8
XFILLER_40_202 VPWR VGND sg13g2_decap_8
XFILLER_40_279 VPWR VGND sg13g2_decap_8
Xclkbuf_4_8_0_clk clknet_0_clk clknet_4_8_0_clk VPWR VGND sg13g2_buf_8
XFILLER_21_493 VPWR VGND sg13g2_decap_8
XFILLER_4_18 VPWR VGND sg13g2_decap_4
XFILLER_4_125 VPWR VGND sg13g2_decap_8
XFILLER_0_364 VPWR VGND sg13g2_decap_8
XFILLER_1_821 VPWR VGND sg13g2_fill_2
XFILLER_49_803 VPWR VGND sg13g2_decap_8
XFILLER_48_357 VPWR VGND sg13g2_decap_8
XFILLER_16_221 VPWR VGND sg13g2_decap_8
XFILLER_16_298 VPWR VGND sg13g2_decap_8
XFILLER_44_574 VPWR VGND sg13g2_decap_8
XFILLER_31_246 VPWR VGND sg13g2_decap_8
XFILLER_8_475 VPWR VGND sg13g2_decap_8
X_0513_ VGND VPWR net24 daisychain\[11\] _0296_ net38 sg13g2_a21oi_1
XFILLER_39_357 VPWR VGND sg13g2_decap_8
XFILLER_10_419 VPWR VGND sg13g2_decap_8
XFILLER_13_27 VPWR VGND sg13g2_decap_8
XFILLER_22_224 VPWR VGND sg13g2_decap_8
XFILLER_23_703 VPWR VGND sg13g2_decap_4
XFILLER_23_725 VPWR VGND sg13g2_decap_8
XFILLER_35_574 VPWR VGND sg13g2_decap_8
Xfanout28 net31 net28 VPWR VGND sg13g2_buf_1
Xfanout39 net40 net39 VPWR VGND sg13g2_buf_1
XFILLER_38_35 VPWR VGND sg13g2_decap_8
XFILLER_13_202 VPWR VGND sg13g2_decap_8
XFILLER_26_530 VPWR VGND sg13g2_decap_8
XFILLER_41_500 VPWR VGND sg13g2_fill_2
XFILLER_41_522 VPWR VGND sg13g2_decap_8
XFILLER_45_316 VPWR VGND sg13g2_decap_8
XFILLER_13_279 VPWR VGND sg13g2_decap_8
XFILLER_21_290 VPWR VGND sg13g2_decap_8
XFILLER_9_228 VPWR VGND sg13g2_decap_8
XFILLER_5_445 VPWR VGND sg13g2_decap_8
XFILLER_0_161 VPWR VGND sg13g2_decap_8
XFILLER_28_90 VPWR VGND sg13g2_decap_8
XFILLER_48_154 VPWR VGND sg13g2_decap_8
XFILLER_49_633 VPWR VGND sg13g2_decap_8
XFILLER_17_596 VPWR VGND sg13g2_decap_8
XFILLER_32_522 VPWR VGND sg13g2_decap_8
XFILLER_32_599 VPWR VGND sg13g2_decap_8
X_0993_ net107 VGND VPWR _0153_ state\[25\] clknet_5_14__leaf_clk sg13g2_dfrbpq_1
XFILLER_9_740 VPWR VGND sg13g2_fill_1
XFILLER_8_272 VPWR VGND sg13g2_decap_8
XFILLER_23_500 VPWR VGND sg13g2_decap_8
XFILLER_35_371 VPWR VGND sg13g2_decap_8
XFILLER_39_154 VPWR VGND sg13g2_decap_8
XFILLER_42_308 VPWR VGND sg13g2_decap_8
XFILLER_10_216 VPWR VGND sg13g2_decap_8
XFILLER_23_577 VPWR VGND sg13g2_decap_8
XFILLER_2_459 VPWR VGND sg13g2_decap_8
XFILLER_40_47 VPWR VGND sg13g2_decap_8
XFILLER_18_349 VPWR VGND sg13g2_decap_8
XFILLER_45_113 VPWR VGND sg13g2_decap_8
XFILLER_49_67 VPWR VGND sg13g2_decap_8
XFILLER_14_544 VPWR VGND sg13g2_decap_8
XFILLER_33_319 VPWR VGND sg13g2_decap_8
XFILLER_41_363 VPWR VGND sg13g2_decap_8
XFILLER_6_743 VPWR VGND sg13g2_fill_1
XFILLER_5_242 VPWR VGND sg13g2_decap_8
XFILLER_46_7 VPWR VGND sg13g2_decap_8
XFILLER_24_308 VPWR VGND sg13g2_decap_8
XFILLER_36_168 VPWR VGND sg13g2_decap_8
Xinput7 ui_in[5] net7 VPWR VGND sg13g2_buf_1
XFILLER_49_452 VPWR VGND sg13g2_decap_8
XFILLER_17_393 VPWR VGND sg13g2_decap_8
XFILLER_20_514 VPWR VGND sg13g2_decap_8
XFILLER_32_396 VPWR VGND sg13g2_decap_8
X_0976_ net104 VGND VPWR _0136_ state\[8\] clknet_5_13__leaf_clk sg13g2_dfrbpq_1
XFILLER_28_636 VPWR VGND sg13g2_decap_8
XFILLER_23_374 VPWR VGND sg13g2_decap_8
XFILLER_27_168 VPWR VGND sg13g2_decap_8
XFILLER_35_14 VPWR VGND sg13g2_decap_8
XFILLER_42_138 VPWR VGND sg13g2_decap_8
XFILLER_43_628 VPWR VGND sg13g2_fill_2
Xclkbuf_5_20__f_clk clknet_5_20__leaf_clk clknet_4_10_0_clk VPWR VGND sg13g2_buf_16
XFILLER_11_547 VPWR VGND sg13g2_decap_8
XFILLER_7_518 VPWR VGND sg13g2_decap_8
XFILLER_2_256 VPWR VGND sg13g2_decap_8
XFILLER_18_146 VPWR VGND sg13g2_decap_8
XFILLER_19_658 VPWR VGND sg13g2_decap_8
XFILLER_33_116 VPWR VGND sg13g2_decap_8
XFILLER_34_606 VPWR VGND sg13g2_decap_8
XFILLER_46_455 VPWR VGND sg13g2_decap_8
XFILLER_14_341 VPWR VGND sg13g2_decap_8
XFILLER_42_661 VPWR VGND sg13g2_fill_2
X_0830_ VPWR _0046_ state\[22\] VGND sg13g2_inv_1
X_0761_ _0382_ VPWR _0169_ VGND net95 _0031_ sg13g2_o21ai_1
X_0692_ _0250_ net57 _0429_ _0430_ VPWR VGND sg13g2_a21o_1
XFILLER_2_95 VPWR VGND sg13g2_decap_8
Xdigitalen1.g\[1\].u.inv1 VPWR digitalen1.g\[1\].u.OUTN net7 VGND sg13g2_inv_1
XFILLER_17_190 VPWR VGND sg13g2_decap_8
XFILLER_24_105 VPWR VGND sg13g2_decap_8
XFILLER_25_606 VPWR VGND sg13g2_decap_8
XFILLER_37_455 VPWR VGND sg13g2_decap_8
XFILLER_20_311 VPWR VGND sg13g2_decap_8
XFILLER_20_388 VPWR VGND sg13g2_decap_8
XFILLER_21_38 VPWR VGND sg13g2_decap_8
XFILLER_32_193 VPWR VGND sg13g2_decap_8
X_0959_ net102 VGND VPWR _0119_ daisychain\[55\] clknet_5_26__leaf_clk sg13g2_dfrbpq_1
XFILLER_16_606 VPWR VGND sg13g2_decap_8
XFILLER_28_433 VPWR VGND sg13g2_decap_8
XFILLER_46_35 VPWR VGND sg13g2_decap_8
XFILLER_11_333 VPWR VGND sg13g2_decap_8
XFILLER_15_149 VPWR VGND sg13g2_decap_8
XFILLER_23_171 VPWR VGND sg13g2_decap_8
XFILLER_24_672 VPWR VGND sg13g2_decap_8
XFILLER_7_315 VPWR VGND sg13g2_decap_8
XFILLER_11_60 VPWR VGND sg13g2_decap_8
XFILLER_3_543 VPWR VGND sg13g2_decap_8
XFILLER_19_455 VPWR VGND sg13g2_decap_8
XFILLER_21_108 VPWR VGND sg13g2_decap_8
XFILLER_22_609 VPWR VGND sg13g2_decap_8
XFILLER_34_403 VPWR VGND sg13g2_decap_8
XFILLER_46_252 VPWR VGND sg13g2_decap_8
XFILLER_47_786 VPWR VGND sg13g2_fill_1
XFILLER_30_664 VPWR VGND sg13g2_decap_8
X_0813_ VPWR _0206_ daisychain\[13\] VGND sg13g2_inv_1
XFILLER_35_0 VPWR VGND sg13g2_decap_8
X_0744_ _0331_ VPWR _0152_ VGND net85 _0048_ sg13g2_o21ai_1
X_0675_ net90 VPWR _0417_ VGND net70 state\[53\] sg13g2_o21ai_1
XFILLER_37_252 VPWR VGND sg13g2_decap_8
XFILLER_32_15 VPWR VGND sg13g2_fill_2
XFILLER_33_480 VPWR VGND sg13g2_decap_8
XFILLER_20_185 VPWR VGND sg13g2_decap_8
XFILLER_21_675 VPWR VGND sg13g2_decap_8
XFILLER_4_307 VPWR VGND sg13g2_decap_8
XFILLER_0_546 VPWR VGND sg13g2_decap_8
XFILLER_48_539 VPWR VGND sg13g2_decap_8
XFILLER_16_403 VPWR VGND sg13g2_decap_8
XFILLER_28_230 VPWR VGND sg13g2_decap_8
XFILLER_29_764 VPWR VGND sg13g2_decap_4
XFILLER_43_255 VPWR VGND sg13g2_decap_8
XFILLER_44_701 VPWR VGND sg13g2_fill_1
XFILLER_11_130 VPWR VGND sg13g2_decap_8
XFILLER_12_686 VPWR VGND sg13g2_decap_4
XFILLER_22_70 VPWR VGND sg13g2_decap_8
XFILLER_31_428 VPWR VGND sg13g2_decap_8
XFILLER_7_112 VPWR VGND sg13g2_decap_8
XFILLER_3_340 VPWR VGND sg13g2_decap_8
X_0460_ VPWR _0024_ state\[63\] VGND sg13g2_inv_1
XFILLER_7_189 VPWR VGND sg13g2_decap_8
XFILLER_19_252 VPWR VGND sg13g2_decap_8
XFILLER_34_200 VPWR VGND sg13g2_decap_8
XFILLER_39_539 VPWR VGND sg13g2_fill_2
X_1012_ net114 VGND VPWR _0172_ state\[44\] clknet_5_21__leaf_clk sg13g2_dfrbpq_1
XFILLER_22_406 VPWR VGND sg13g2_decap_8
XFILLER_34_277 VPWR VGND sg13g2_decap_8
Xheichips25_pudding_124 VPWR VGND uio_oe[5] sg13g2_tiehi
XFILLER_30_461 VPWR VGND sg13g2_decap_8
X_0727_ _0280_ VPWR _0135_ VGND net81 _0061_ sg13g2_o21ai_1
XFILLER_8_83 VPWR VGND sg13g2_decap_8
X_0658_ _0112_ _0403_ _0404_ net53 _0241_ VPWR VGND sg13g2_a22oi_1
X_0589_ VGND VPWR net26 daisychain\[30\] _0353_ net42 sg13g2_a21oi_1
XFILLER_25_244 VPWR VGND sg13g2_decap_8
XFILLER_26_712 VPWR VGND sg13g2_decap_8
XFILLER_43_14 VPWR VGND sg13g2_decap_8
XFILLER_21_472 VPWR VGND sg13g2_decap_8
XFILLER_40_258 VPWR VGND sg13g2_decap_8
XFILLER_5_605 VPWR VGND sg13g2_fill_1
XFILLER_5_638 VPWR VGND sg13g2_fill_2
XFILLER_4_104 VPWR VGND sg13g2_decap_8
XFILLER_0_343 VPWR VGND sg13g2_decap_8
XFILLER_29_572 VPWR VGND sg13g2_decap_4
XFILLER_48_336 VPWR VGND sg13g2_decap_8
XFILLER_16_200 VPWR VGND sg13g2_decap_8
XFILLER_16_277 VPWR VGND sg13g2_decap_8
XFILLER_17_92 VPWR VGND sg13g2_decap_8
XFILLER_31_225 VPWR VGND sg13g2_decap_8
XFILLER_44_553 VPWR VGND sg13g2_decap_8
XFILLER_12_494 VPWR VGND sg13g2_decap_8
XFILLER_8_454 VPWR VGND sg13g2_decap_8
X_0512_ _0205_ net63 _0294_ _0295_ VPWR VGND sg13g2_a21o_1
XFILLER_35_553 VPWR VGND sg13g2_decap_8
XFILLER_39_336 VPWR VGND sg13g2_decap_8
XFILLER_22_203 VPWR VGND sg13g2_decap_8
Xclkbuf_5_1__f_clk clknet_5_1__leaf_clk clknet_4_0_0_clk VPWR VGND sg13g2_buf_16
Xfanout29 net31 net29 VPWR VGND sg13g2_buf_1
XFILLER_2_608 VPWR VGND sg13g2_fill_2
XFILLER_2_619 VPWR VGND sg13g2_fill_1
XFILLER_38_14 VPWR VGND sg13g2_decap_8
XFILLER_13_258 VPWR VGND sg13g2_decap_8
XFILLER_26_586 VPWR VGND sg13g2_decap_8
XFILLER_9_207 VPWR VGND sg13g2_decap_8
XFILLER_22_781 VPWR VGND sg13g2_fill_2
XFILLER_41_578 VPWR VGND sg13g2_decap_4
XFILLER_5_424 VPWR VGND sg13g2_decap_8
XFILLER_0_140 VPWR VGND sg13g2_decap_8
XFILLER_29_391 VPWR VGND sg13g2_decap_8
XFILLER_48_133 VPWR VGND sg13g2_decap_8
XFILLER_13_781 VPWR VGND sg13g2_fill_2
XFILLER_13_792 VPWR VGND sg13g2_fill_2
XFILLER_17_575 VPWR VGND sg13g2_decap_8
XFILLER_32_501 VPWR VGND sg13g2_decap_8
XFILLER_32_578 VPWR VGND sg13g2_decap_8
XFILLER_44_383 VPWR VGND sg13g2_decap_8
X_0992_ net107 VGND VPWR _0152_ state\[24\] clknet_5_6__leaf_clk sg13g2_dfrbpq_1
XFILLER_8_251 VPWR VGND sg13g2_decap_8
XFILLER_39_133 VPWR VGND sg13g2_decap_8
Xclkbuf_4_7_0_clk clknet_0_clk clknet_4_7_0_clk VPWR VGND sg13g2_buf_8
XFILLER_5_95 VPWR VGND sg13g2_decap_8
XFILLER_23_556 VPWR VGND sg13g2_decap_8
XFILLER_24_49 VPWR VGND sg13g2_decap_8
XFILLER_35_350 VPWR VGND sg13g2_decap_8
XFILLER_2_438 VPWR VGND sg13g2_decap_8
XFILLER_49_46 VPWR VGND sg13g2_decap_8
XFILLER_18_328 VPWR VGND sg13g2_decap_8
XFILLER_45_169 VPWR VGND sg13g2_decap_8
XFILLER_14_523 VPWR VGND sg13g2_decap_8
XFILLER_26_383 VPWR VGND sg13g2_decap_8
XFILLER_41_342 VPWR VGND sg13g2_decap_8
XFILLER_14_82 VPWR VGND sg13g2_decap_8
XFILLER_5_298 VPWR VGND sg13g2_decap_8
XFILLER_5_221 VPWR VGND sg13g2_decap_8
XFILLER_49_431 VPWR VGND sg13g2_decap_8
XFILLER_17_372 VPWR VGND sg13g2_decap_8
XFILLER_36_147 VPWR VGND sg13g2_decap_8
XFILLER_44_180 VPWR VGND sg13g2_decap_8
XFILLER_45_670 VPWR VGND sg13g2_fill_2
XFILLER_32_375 VPWR VGND sg13g2_decap_8
X_0975_ net103 VGND VPWR _0135_ state\[7\] clknet_5_13__leaf_clk sg13g2_dfrbpq_1
XFILLER_9_560 VPWR VGND sg13g2_decap_8
XFILLER_19_49 VPWR VGND sg13g2_decap_8
XFILLER_27_147 VPWR VGND sg13g2_decap_8
XFILLER_28_615 VPWR VGND sg13g2_decap_8
XFILLER_11_526 VPWR VGND sg13g2_decap_8
XFILLER_23_353 VPWR VGND sg13g2_decap_8
XFILLER_24_821 VPWR VGND sg13g2_fill_2
XFILLER_42_117 VPWR VGND sg13g2_decap_8
XFILLER_2_235 VPWR VGND sg13g2_decap_8
XFILLER_4_4 VPWR VGND sg13g2_decap_8
XFILLER_14_320 VPWR VGND sg13g2_decap_8
XFILLER_15_810 VPWR VGND sg13g2_decap_8
XFILLER_15_821 VPWR VGND sg13g2_fill_2
XFILLER_18_125 VPWR VGND sg13g2_decap_8
XFILLER_19_637 VPWR VGND sg13g2_decap_8
XFILLER_26_180 VPWR VGND sg13g2_decap_8
XFILLER_46_434 VPWR VGND sg13g2_decap_8
XFILLER_14_397 VPWR VGND sg13g2_decap_8
XFILLER_41_150 VPWR VGND sg13g2_decap_4
X_0760_ _0379_ VPWR _0168_ VGND net96 _0030_ sg13g2_o21ai_1
XFILLER_41_80 VPWR VGND sg13g2_decap_8
X_0691_ net80 VPWR _0429_ VGND net57 state\[57\] sg13g2_o21ai_1
XFILLER_6_552 VPWR VGND sg13g2_fill_1
XFILLER_2_74 VPWR VGND sg13g2_decap_8
XFILLER_37_434 VPWR VGND sg13g2_decap_8
Xdigitalen1.g\[1\].u.inv2 VPWR digitalen1.g\[1\].u.OUTP digitalen1.g\[1\].u.OUTN VGND
+ sg13g2_inv_1
XFILLER_32_172 VPWR VGND sg13g2_decap_8
XFILLER_33_662 VPWR VGND sg13g2_fill_2
XFILLER_20_367 VPWR VGND sg13g2_decap_8
X_0889_ VPWR _0244_ daisychain\[51\] VGND sg13g2_inv_1
X_0958_ net112 VGND VPWR _0118_ daisychain\[54\] clknet_5_27__leaf_clk sg13g2_dfrbpq_1
XFILLER_0_717 VPWR VGND sg13g2_decap_4
XFILLER_15_128 VPWR VGND sg13g2_decap_8
XFILLER_28_412 VPWR VGND sg13g2_decap_8
XFILLER_28_489 VPWR VGND sg13g2_decap_8
XFILLER_43_437 VPWR VGND sg13g2_decap_4
XFILLER_46_14 VPWR VGND sg13g2_decap_8
XFILLER_11_312 VPWR VGND sg13g2_decap_8
XFILLER_11_389 VPWR VGND sg13g2_decap_8
XFILLER_23_150 VPWR VGND sg13g2_decap_8
XFILLER_24_651 VPWR VGND sg13g2_decap_8
XFILLER_3_522 VPWR VGND sg13g2_decap_8
XFILLER_19_434 VPWR VGND sg13g2_decap_8
XFILLER_46_231 VPWR VGND sg13g2_decap_8
XFILLER_47_732 VPWR VGND sg13g2_fill_1
XFILLER_15_640 VPWR VGND sg13g2_fill_2
XFILLER_34_459 VPWR VGND sg13g2_decap_8
XFILLER_36_91 VPWR VGND sg13g2_decap_8
XFILLER_14_194 VPWR VGND sg13g2_decap_8
XFILLER_30_643 VPWR VGND sg13g2_decap_8
XFILLER_42_492 VPWR VGND sg13g2_decap_8
X_0812_ VPWR _0036_ state\[13\] VGND sg13g2_inv_1
X_0743_ _0328_ VPWR _0151_ VGND net88 _0047_ sg13g2_o21ai_1
XFILLER_29_209 VPWR VGND sg13g2_decap_8
X_0674_ _0116_ _0415_ _0416_ net47 _0245_ VPWR VGND sg13g2_a22oi_1
XFILLER_6_382 VPWR VGND sg13g2_decap_8
XFILLER_16_39 VPWR VGND sg13g2_decap_8
XFILLER_37_231 VPWR VGND sg13g2_decap_8
XFILLER_38_732 VPWR VGND sg13g2_fill_2
XFILLER_20_164 VPWR VGND sg13g2_decap_8
XFILLER_21_654 VPWR VGND sg13g2_decap_8
XFILLER_25_459 VPWR VGND sg13g2_decap_8
XFILLER_0_525 VPWR VGND sg13g2_decap_8
XFILLER_48_518 VPWR VGND sg13g2_decap_8
XFILLER_16_459 VPWR VGND sg13g2_decap_8
XFILLER_28_286 VPWR VGND sg13g2_decap_8
XFILLER_31_407 VPWR VGND sg13g2_decap_8
XFILLER_43_234 VPWR VGND sg13g2_decap_8
XFILLER_11_186 VPWR VGND sg13g2_decap_8
XFILLER_7_168 VPWR VGND sg13g2_decap_8
XFILLER_3_396 VPWR VGND sg13g2_decap_8
XFILLER_19_231 VPWR VGND sg13g2_decap_8
XFILLER_39_518 VPWR VGND sg13g2_decap_8
XFILLER_47_595 VPWR VGND sg13g2_decap_8
X_1011_ net114 VGND VPWR _0171_ state\[43\] clknet_5_20__leaf_clk sg13g2_dfrbpq_1
XFILLER_15_492 VPWR VGND sg13g2_decap_8
XFILLER_30_440 VPWR VGND sg13g2_decap_8
XFILLER_34_256 VPWR VGND sg13g2_decap_8
Xheichips25_pudding_125 VPWR VGND uio_oe[6] sg13g2_tiehi
X_0726_ _0277_ VPWR _0134_ VGND net81 _0060_ sg13g2_o21ai_1
XFILLER_8_62 VPWR VGND sg13g2_decap_8
X_0657_ VGND VPWR net30 daisychain\[47\] _0404_ net53 sg13g2_a21oi_1
X_0588_ _0224_ net67 _0351_ _0352_ VPWR VGND sg13g2_a21o_1
XFILLER_25_223 VPWR VGND sg13g2_decap_8
XFILLER_27_49 VPWR VGND sg13g2_decap_8
XFILLER_38_595 VPWR VGND sg13g2_decap_8
XFILLER_21_451 VPWR VGND sg13g2_decap_8
XFILLER_40_237 VPWR VGND sg13g2_decap_8
XFILLER_43_59 VPWR VGND sg13g2_decap_8
XFILLER_5_617 VPWR VGND sg13g2_decap_8
XFILLER_0_322 VPWR VGND sg13g2_decap_8
XFILLER_0_399 VPWR VGND sg13g2_decap_8
XFILLER_48_315 VPWR VGND sg13g2_decap_8
XFILLER_12_473 VPWR VGND sg13g2_decap_8
XFILLER_16_256 VPWR VGND sg13g2_decap_8
XFILLER_17_71 VPWR VGND sg13g2_decap_8
XFILLER_31_204 VPWR VGND sg13g2_decap_8
XFILLER_33_81 VPWR VGND sg13g2_decap_8
X_0511_ net84 VPWR _0294_ VGND net63 state\[12\] sg13g2_o21ai_1
XFILLER_8_433 VPWR VGND sg13g2_decap_8
XFILLER_39_315 VPWR VGND sg13g2_decap_8
XFILLER_3_193 VPWR VGND sg13g2_decap_8
XFILLER_4_694 VPWR VGND sg13g2_decap_8
XFILLER_4_683 VPWR VGND sg13g2_fill_1
XFILLER_35_532 VPWR VGND sg13g2_decap_8
XFILLER_47_392 VPWR VGND sg13g2_decap_8
XFILLER_22_259 VPWR VGND sg13g2_decap_8
XFILLER_1_119 VPWR VGND sg13g2_decap_8
X_0709_ VGND VPWR net34 daisychain\[60\] _0443_ net35 sg13g2_a21oi_1
XFILLER_13_237 VPWR VGND sg13g2_decap_8
XFILLER_26_565 VPWR VGND sg13g2_decap_8
XFILLER_38_392 VPWR VGND sg13g2_decap_8
XFILLER_41_557 VPWR VGND sg13g2_decap_8
XFILLER_5_403 VPWR VGND sg13g2_decap_8
XFILLER_0_196 VPWR VGND sg13g2_decap_8
XFILLER_48_112 VPWR VGND sg13g2_decap_8
XFILLER_49_613 VPWR VGND sg13g2_decap_8
XFILLER_17_554 VPWR VGND sg13g2_decap_8
XFILLER_29_370 VPWR VGND sg13g2_decap_8
XFILLER_36_329 VPWR VGND sg13g2_decap_8
XFILLER_44_362 VPWR VGND sg13g2_decap_8
XFILLER_48_189 VPWR VGND sg13g2_decap_8
XFILLER_49_668 VPWR VGND sg13g2_fill_2
XFILLER_32_557 VPWR VGND sg13g2_decap_8
X_0991_ net109 VGND VPWR _0151_ state\[23\] clknet_5_1__leaf_clk sg13g2_dfrbpq_1
XFILLER_9_731 VPWR VGND sg13g2_decap_8
XFILLER_8_230 VPWR VGND sg13g2_decap_8
XFILLER_5_74 VPWR VGND sg13g2_decap_8
XFILLER_27_329 VPWR VGND sg13g2_decap_8
XFILLER_39_112 VPWR VGND sg13g2_decap_8
XFILLER_39_189 VPWR VGND sg13g2_decap_8
XFILLER_23_535 VPWR VGND sg13g2_decap_8
XFILLER_2_417 VPWR VGND sg13g2_decap_8
XFILLER_49_25 VPWR VGND sg13g2_decap_8
XFILLER_14_502 VPWR VGND sg13g2_decap_8
XFILLER_18_307 VPWR VGND sg13g2_decap_8
XFILLER_26_362 VPWR VGND sg13g2_decap_8
XFILLER_45_148 VPWR VGND sg13g2_decap_8
XFILLER_46_616 VPWR VGND sg13g2_fill_2
XFILLER_10_730 VPWR VGND sg13g2_fill_2
XFILLER_14_579 VPWR VGND sg13g2_decap_8
XFILLER_14_61 VPWR VGND sg13g2_decap_8
XFILLER_41_321 VPWR VGND sg13g2_decap_8
XFILLER_41_398 VPWR VGND sg13g2_decap_8
XFILLER_5_277 VPWR VGND sg13g2_decap_8
XFILLER_5_200 VPWR VGND sg13g2_decap_8
XFILLER_1_483 VPWR VGND sg13g2_decap_8
XFILLER_36_126 VPWR VGND sg13g2_decap_8
XFILLER_37_616 VPWR VGND sg13g2_decap_8
XFILLER_39_91 VPWR VGND sg13g2_decap_8
XFILLER_49_487 VPWR VGND sg13g2_decap_8
XFILLER_49_410 VPWR VGND sg13g2_decap_8
XFILLER_17_351 VPWR VGND sg13g2_decap_8
XFILLER_32_354 VPWR VGND sg13g2_decap_8
XFILLER_20_549 VPWR VGND sg13g2_decap_8
X_0974_ net104 VGND VPWR _0134_ state\[6\] clknet_5_13__leaf_clk sg13g2_dfrbpq_1
XFILLER_19_28 VPWR VGND sg13g2_decap_8
XFILLER_27_126 VPWR VGND sg13g2_decap_8
XFILLER_35_49 VPWR VGND sg13g2_decap_8
XFILLER_36_671 VPWR VGND sg13g2_decap_4
XFILLER_11_505 VPWR VGND sg13g2_decap_8
XFILLER_23_332 VPWR VGND sg13g2_decap_8
XFILLER_2_214 VPWR VGND sg13g2_decap_8
XFILLER_3_704 VPWR VGND sg13g2_fill_2
XFILLER_18_104 VPWR VGND sg13g2_decap_8
XFILLER_19_616 VPWR VGND sg13g2_decap_8
XFILLER_46_413 VPWR VGND sg13g2_decap_8
XFILLER_27_693 VPWR VGND sg13g2_decap_8
XFILLER_30_803 VPWR VGND sg13g2_fill_1
XFILLER_30_814 VPWR VGND sg13g2_decap_8
XFILLER_42_663 VPWR VGND sg13g2_fill_1
XFILLER_10_560 VPWR VGND sg13g2_decap_8
XFILLER_14_376 VPWR VGND sg13g2_decap_8
XFILLER_41_195 VPWR VGND sg13g2_decap_8
Xclkbuf_4_6_0_clk clknet_0_clk clknet_4_6_0_clk VPWR VGND sg13g2_buf_8
X_0690_ _0120_ _0427_ _0428_ net48 _0249_ VPWR VGND sg13g2_a22oi_1
XFILLER_2_781 VPWR VGND sg13g2_fill_1
XFILLER_2_792 VPWR VGND sg13g2_decap_4
XFILLER_18_671 VPWR VGND sg13g2_decap_8
XFILLER_1_280 VPWR VGND sg13g2_decap_8
XFILLER_2_53 VPWR VGND sg13g2_decap_8
XFILLER_37_413 VPWR VGND sg13g2_decap_8
XFILLER_49_284 VPWR VGND sg13g2_decap_8
XFILLER_20_346 VPWR VGND sg13g2_decap_8
XFILLER_32_151 VPWR VGND sg13g2_decap_8
XFILLER_33_641 VPWR VGND sg13g2_decap_8
X_0888_ VPWR _0010_ state\[51\] VGND sg13g2_inv_1
X_0957_ net112 VGND VPWR _0117_ daisychain\[53\] clknet_5_27__leaf_clk sg13g2_dfrbpq_1
XFILLER_15_107 VPWR VGND sg13g2_decap_8
XFILLER_24_630 VPWR VGND sg13g2_decap_8
XFILLER_28_468 VPWR VGND sg13g2_decap_8
XFILLER_36_490 VPWR VGND sg13g2_decap_8
XFILLER_43_416 VPWR VGND sg13g2_decap_8
XFILLER_11_368 VPWR VGND sg13g2_decap_8
XFILLER_11_95 VPWR VGND sg13g2_decap_8
XFILLER_3_501 VPWR VGND sg13g2_decap_8
XFILLER_19_413 VPWR VGND sg13g2_decap_8
XFILLER_46_210 VPWR VGND sg13g2_decap_8
XFILLER_14_173 VPWR VGND sg13g2_decap_8
XFILLER_27_490 VPWR VGND sg13g2_decap_8
XFILLER_30_622 VPWR VGND sg13g2_decap_8
XFILLER_34_438 VPWR VGND sg13g2_decap_8
XFILLER_36_70 VPWR VGND sg13g2_decap_8
XFILLER_46_287 VPWR VGND sg13g2_decap_8
XFILLER_30_699 VPWR VGND sg13g2_decap_4
X_0811_ VPWR _0205_ daisychain\[12\] VGND sg13g2_inv_1
X_0742_ _0325_ VPWR _0150_ VGND net88 _0046_ sg13g2_o21ai_1
X_0673_ VGND VPWR net28 daisychain\[51\] _0416_ net47 sg13g2_a21oi_1
XFILLER_6_361 VPWR VGND sg13g2_decap_8
XFILLER_25_405 VPWR VGND sg13g2_decap_8
XFILLER_25_438 VPWR VGND sg13g2_decap_8
XFILLER_37_210 VPWR VGND sg13g2_decap_8
XFILLER_37_287 VPWR VGND sg13g2_decap_8
XFILLER_20_143 VPWR VGND sg13g2_decap_8
XFILLER_21_633 VPWR VGND sg13g2_decap_8
XFILLER_32_39 VPWR VGND sg13g2_decap_8
XFILLER_40_419 VPWR VGND sg13g2_decap_8
XFILLER_0_504 VPWR VGND sg13g2_decap_8
XFILLER_28_265 VPWR VGND sg13g2_decap_8
XFILLER_29_733 VPWR VGND sg13g2_decap_4
XFILLER_16_438 VPWR VGND sg13g2_decap_8
XFILLER_43_213 VPWR VGND sg13g2_decap_8
XFILLER_11_165 VPWR VGND sg13g2_decap_8
XFILLER_7_147 VPWR VGND sg13g2_decap_8
XFILLER_3_375 VPWR VGND sg13g2_decap_8
XFILLER_19_210 VPWR VGND sg13g2_decap_8
XFILLER_19_287 VPWR VGND sg13g2_decap_8
XFILLER_34_235 VPWR VGND sg13g2_decap_8
XFILLER_47_574 VPWR VGND sg13g2_decap_8
XFILLER_47_91 VPWR VGND sg13g2_decap_8
X_1010_ net114 VGND VPWR _0170_ state\[42\] clknet_5_16__leaf_clk sg13g2_dfrbpq_1
Xheichips25_pudding_126 VPWR VGND uio_oe[7] sg13g2_tiehi
XFILLER_15_471 VPWR VGND sg13g2_decap_8
XFILLER_30_496 VPWR VGND sg13g2_decap_8
XFILLER_8_41 VPWR VGND sg13g2_decap_8
XFILLER_40_0 VPWR VGND sg13g2_decap_8
X_0725_ _0274_ VPWR _0133_ VGND net81 _0059_ sg13g2_o21ai_1
X_0656_ _0241_ net75 _0402_ _0403_ VPWR VGND sg13g2_a21o_1
XFILLER_27_28 VPWR VGND sg13g2_decap_8
XFILLER_38_574 VPWR VGND sg13g2_decap_8
X_0587_ net88 VPWR _0351_ VGND net67 state\[31\] sg13g2_o21ai_1
XFILLER_21_430 VPWR VGND sg13g2_decap_8
XFILLER_25_202 VPWR VGND sg13g2_decap_8
XFILLER_25_279 VPWR VGND sg13g2_decap_8
XFILLER_26_747 VPWR VGND sg13g2_decap_8
XFILLER_40_216 VPWR VGND sg13g2_decap_8
XFILLER_41_706 VPWR VGND sg13g2_fill_1
XFILLER_4_139 VPWR VGND sg13g2_decap_8
XFILLER_0_301 VPWR VGND sg13g2_decap_8
XFILLER_0_378 VPWR VGND sg13g2_decap_8
XFILLER_49_817 VPWR VGND sg13g2_decap_4
XFILLER_16_235 VPWR VGND sg13g2_decap_8
XFILLER_29_541 VPWR VGND sg13g2_decap_8
XFILLER_44_522 VPWR VGND sg13g2_decap_4
Xclkbuf_5_26__f_clk clknet_5_26__leaf_clk clknet_4_13_0_clk VPWR VGND sg13g2_buf_16
XFILLER_12_452 VPWR VGND sg13g2_decap_8
XFILLER_33_60 VPWR VGND sg13g2_decap_8
XFILLER_44_588 VPWR VGND sg13g2_fill_1
XFILLER_8_412 VPWR VGND sg13g2_decap_8
XFILLER_3_172 VPWR VGND sg13g2_decap_8
X_0510_ _0075_ _0292_ _0293_ net38 _0204_ VPWR VGND sg13g2_a22oi_1
XFILLER_8_489 VPWR VGND sg13g2_decap_8
XFILLER_12_4 VPWR VGND sg13g2_decap_4
XFILLER_22_238 VPWR VGND sg13g2_decap_8
XFILLER_35_511 VPWR VGND sg13g2_decap_8
XFILLER_35_588 VPWR VGND sg13g2_decap_8
XFILLER_47_371 VPWR VGND sg13g2_decap_8
XFILLER_30_293 VPWR VGND sg13g2_decap_8
Xdigitalen0.g\[2\].u.inv1 VPWR digitalen0.g\[2\].u.OUTN net6 VGND sg13g2_inv_1
X_0708_ _0254_ net57 _0441_ _0442_ VPWR VGND sg13g2_a21o_1
X_0639_ net94 VPWR _0390_ VGND net72 state\[44\] sg13g2_o21ai_1
XFILLER_26_544 VPWR VGND sg13g2_decap_8
XFILLER_38_371 VPWR VGND sg13g2_decap_8
XFILLER_38_49 VPWR VGND sg13g2_decap_8
XFILLER_13_216 VPWR VGND sg13g2_decap_8
XFILLER_41_536 VPWR VGND sg13g2_decap_8
XFILLER_5_459 VPWR VGND sg13g2_decap_8
XFILLER_0_175 VPWR VGND sg13g2_decap_8
XFILLER_36_308 VPWR VGND sg13g2_decap_8
XFILLER_48_168 VPWR VGND sg13g2_decap_8
XFILLER_49_647 VPWR VGND sg13g2_decap_8
XFILLER_17_533 VPWR VGND sg13g2_decap_8
XFILLER_32_536 VPWR VGND sg13g2_decap_8
XFILLER_44_341 VPWR VGND sg13g2_decap_8
XFILLER_12_293 VPWR VGND sg13g2_decap_8
XFILLER_13_783 VPWR VGND sg13g2_fill_1
XFILLER_13_794 VPWR VGND sg13g2_fill_1
X_0990_ net108 VGND VPWR _0150_ state\[22\] clknet_5_3__leaf_clk sg13g2_dfrbpq_1
XFILLER_8_286 VPWR VGND sg13g2_decap_8
XFILLER_5_53 VPWR VGND sg13g2_decap_8
XFILLER_27_308 VPWR VGND sg13g2_decap_8
XFILLER_39_168 VPWR VGND sg13g2_decap_8
XFILLER_23_514 VPWR VGND sg13g2_decap_8
XFILLER_35_385 VPWR VGND sg13g2_decap_8
XFILLER_26_341 VPWR VGND sg13g2_decap_8
XFILLER_41_300 VPWR VGND sg13g2_decap_8
XFILLER_45_127 VPWR VGND sg13g2_decap_8
XFILLER_14_40 VPWR VGND sg13g2_decap_8
XFILLER_14_558 VPWR VGND sg13g2_decap_8
XFILLER_41_377 VPWR VGND sg13g2_decap_8
XFILLER_1_462 VPWR VGND sg13g2_decap_8
XFILLER_30_83 VPWR VGND sg13g2_decap_8
XFILLER_5_256 VPWR VGND sg13g2_decap_8
XFILLER_17_330 VPWR VGND sg13g2_decap_8
XFILLER_36_105 VPWR VGND sg13g2_decap_8
XFILLER_39_70 VPWR VGND sg13g2_decap_8
XFILLER_49_466 VPWR VGND sg13g2_decap_8
XFILLER_20_528 VPWR VGND sg13g2_decap_8
XFILLER_32_333 VPWR VGND sg13g2_decap_8
XFILLER_13_591 VPWR VGND sg13g2_decap_8
X_0973_ net103 VGND VPWR _0133_ state\[5\] clknet_5_13__leaf_clk sg13g2_dfrbpq_1
XFILLER_23_311 VPWR VGND sg13g2_decap_8
XFILLER_27_105 VPWR VGND sg13g2_decap_8
XFILLER_35_182 VPWR VGND sg13g2_decap_8
XFILLER_35_28 VPWR VGND sg13g2_decap_8
XFILLER_23_388 VPWR VGND sg13g2_decap_8
XFILLER_14_355 VPWR VGND sg13g2_decap_8
XFILLER_25_83 VPWR VGND sg13g2_decap_8
XFILLER_27_672 VPWR VGND sg13g2_decap_8
XFILLER_41_174 VPWR VGND sg13g2_decap_8
XFILLER_42_653 VPWR VGND sg13g2_fill_1
XFILLER_46_469 VPWR VGND sg13g2_decap_8
XFILLER_10_583 VPWR VGND sg13g2_decap_8
XFILLER_6_587 VPWR VGND sg13g2_fill_1
XFILLER_6_543 VPWR VGND sg13g2_decap_8
XFILLER_2_32 VPWR VGND sg13g2_decap_8
XFILLER_44_7 VPWR VGND sg13g2_decap_8
Xheichips25_pudding VPWR VGND uio_oe[0] sg13g2_tiehi
XFILLER_18_650 VPWR VGND sg13g2_decap_8
XFILLER_18_694 VPWR VGND sg13g2_fill_2
XFILLER_24_119 VPWR VGND sg13g2_decap_8
XFILLER_33_620 VPWR VGND sg13g2_decap_8
XFILLER_37_469 VPWR VGND sg13g2_decap_8
XFILLER_45_491 VPWR VGND sg13g2_decap_8
XFILLER_49_263 VPWR VGND sg13g2_decap_8
XFILLER_20_325 VPWR VGND sg13g2_decap_8
XFILLER_32_130 VPWR VGND sg13g2_decap_8
XFILLER_33_664 VPWR VGND sg13g2_fill_1
X_0956_ net112 VGND VPWR _0116_ daisychain\[52\] clknet_5_30__leaf_clk sg13g2_dfrbpq_1
X_0887_ VPWR _0243_ daisychain\[50\] VGND sg13g2_inv_1
XFILLER_28_447 VPWR VGND sg13g2_decap_8
XFILLER_46_49 VPWR VGND sg13g2_decap_8
Xclkbuf_5_7__f_clk clknet_5_7__leaf_clk clknet_4_3_0_clk VPWR VGND sg13g2_buf_16
XFILLER_24_686 VPWR VGND sg13g2_decap_8
XFILLER_11_347 VPWR VGND sg13g2_decap_8
XFILLER_23_185 VPWR VGND sg13g2_decap_8
XFILLER_7_329 VPWR VGND sg13g2_decap_8
XFILLER_11_74 VPWR VGND sg13g2_decap_8
XFILLER_3_557 VPWR VGND sg13g2_decap_8
XFILLER_19_469 VPWR VGND sg13g2_decap_8
XFILLER_34_417 VPWR VGND sg13g2_decap_8
XFILLER_46_266 VPWR VGND sg13g2_decap_8
XFILLER_47_712 VPWR VGND sg13g2_fill_2
XFILLER_47_778 VPWR VGND sg13g2_fill_2
XFILLER_14_152 VPWR VGND sg13g2_decap_8
XFILLER_15_642 VPWR VGND sg13g2_fill_1
XFILLER_30_601 VPWR VGND sg13g2_decap_8
XFILLER_30_678 VPWR VGND sg13g2_decap_8
X_0810_ VPWR _0035_ state\[12\] VGND sg13g2_inv_1
XFILLER_10_391 VPWR VGND sg13g2_decap_8
X_0741_ _0322_ VPWR _0149_ VGND net87 _0045_ sg13g2_o21ai_1
X_0672_ _0245_ net69 _0414_ _0415_ VPWR VGND sg13g2_a21o_1
XFILLER_6_340 VPWR VGND sg13g2_decap_8
XFILLER_21_612 VPWR VGND sg13g2_decap_8
XFILLER_37_266 VPWR VGND sg13g2_decap_8
XFILLER_20_122 VPWR VGND sg13g2_decap_8
XFILLER_20_199 VPWR VGND sg13g2_decap_8
XFILLER_21_689 VPWR VGND sg13g2_decap_8
XFILLER_33_494 VPWR VGND sg13g2_decap_8
X_0939_ net112 VGND VPWR _0099_ daisychain\[35\] clknet_5_25__leaf_clk sg13g2_dfrbpq_1
XFILLER_16_417 VPWR VGND sg13g2_decap_8
XFILLER_28_244 VPWR VGND sg13g2_decap_8
XFILLER_29_712 VPWR VGND sg13g2_decap_8
Xclkbuf_4_5_0_clk clknet_0_clk clknet_4_5_0_clk VPWR VGND sg13g2_buf_8
XFILLER_11_144 VPWR VGND sg13g2_decap_8
XFILLER_24_483 VPWR VGND sg13g2_decap_8
XFILLER_43_269 VPWR VGND sg13g2_decap_8
XFILLER_22_84 VPWR VGND sg13g2_decap_8
XFILLER_3_354 VPWR VGND sg13g2_decap_8
XFILLER_7_126 VPWR VGND sg13g2_decap_8
XFILLER_0_0 VPWR VGND sg13g2_decap_8
XFILLER_14_8 VPWR VGND sg13g2_decap_4
XFILLER_15_450 VPWR VGND sg13g2_decap_8
XFILLER_19_266 VPWR VGND sg13g2_decap_8
XFILLER_34_214 VPWR VGND sg13g2_decap_8
XFILLER_47_553 VPWR VGND sg13g2_decap_8
XFILLER_47_70 VPWR VGND sg13g2_decap_8
XFILLER_30_475 VPWR VGND sg13g2_decap_8
XFILLER_42_280 VPWR VGND sg13g2_decap_8
XFILLER_8_97 VPWR VGND sg13g2_decap_8
XFILLER_8_20 VPWR VGND sg13g2_decap_8
X_0724_ _0271_ VPWR _0132_ VGND net99 _0058_ sg13g2_o21ai_1
X_0655_ net97 VPWR _0402_ VGND net75 state\[48\] sg13g2_o21ai_1
X_0586_ _0094_ _0349_ _0350_ net55 _0223_ VPWR VGND sg13g2_a22oi_1
XFILLER_7_693 VPWR VGND sg13g2_fill_2
XFILLER_7_682 VPWR VGND sg13g2_fill_1
XFILLER_26_726 VPWR VGND sg13g2_decap_8
XFILLER_38_553 VPWR VGND sg13g2_decap_8
XFILLER_25_258 VPWR VGND sg13g2_decap_8
XFILLER_33_291 VPWR VGND sg13g2_decap_8
XFILLER_43_28 VPWR VGND sg13g2_decap_4
XFILLER_21_486 VPWR VGND sg13g2_decap_8
XFILLER_4_118 VPWR VGND sg13g2_decap_8
XFILLER_0_357 VPWR VGND sg13g2_decap_8
XFILLER_16_214 VPWR VGND sg13g2_decap_8
XFILLER_44_501 VPWR VGND sg13g2_decap_8
XFILLER_44_567 VPWR VGND sg13g2_decap_8
XFILLER_12_431 VPWR VGND sg13g2_decap_8
XFILLER_24_280 VPWR VGND sg13g2_decap_8
XFILLER_25_792 VPWR VGND sg13g2_fill_2
XFILLER_31_239 VPWR VGND sg13g2_decap_8
XFILLER_8_468 VPWR VGND sg13g2_decap_8
XFILLER_3_151 VPWR VGND sg13g2_decap_8
XFILLER_47_350 VPWR VGND sg13g2_decap_8
XFILLER_22_217 VPWR VGND sg13g2_decap_8
XFILLER_23_707 VPWR VGND sg13g2_fill_2
XFILLER_23_718 VPWR VGND sg13g2_decap_8
XFILLER_35_567 VPWR VGND sg13g2_decap_8
XFILLER_30_272 VPWR VGND sg13g2_decap_8
Xdigitalen0.g\[2\].u.inv2 VPWR digitalen0.g\[2\].u.OUTP digitalen0.g\[2\].u.OUTN VGND
+ sg13g2_inv_1
X_0707_ net80 VPWR _0441_ VGND net57 state\[61\] sg13g2_o21ai_1
XFILLER_7_490 VPWR VGND sg13g2_decap_8
XFILLER_38_28 VPWR VGND sg13g2_decap_8
X_0638_ _0107_ _0388_ _0389_ net50 _0236_ VPWR VGND sg13g2_a22oi_1
X_0569_ VGND VPWR net25 daisychain\[25\] _0338_ net38 sg13g2_a21oi_1
XFILLER_26_523 VPWR VGND sg13g2_decap_8
XFILLER_38_350 VPWR VGND sg13g2_decap_8
XFILLER_41_515 VPWR VGND sg13g2_decap_8
XFILLER_45_309 VPWR VGND sg13g2_decap_8
XFILLER_21_283 VPWR VGND sg13g2_decap_8
XFILLER_22_773 VPWR VGND sg13g2_fill_1
XFILLER_5_438 VPWR VGND sg13g2_decap_8
XFILLER_0_154 VPWR VGND sg13g2_decap_8
XFILLER_17_512 VPWR VGND sg13g2_decap_8
XFILLER_28_83 VPWR VGND sg13g2_decap_8
XFILLER_48_147 VPWR VGND sg13g2_decap_8
XFILLER_17_589 VPWR VGND sg13g2_decap_8
XFILLER_32_515 VPWR VGND sg13g2_decap_8
XFILLER_44_320 VPWR VGND sg13g2_decap_8
XFILLER_44_397 VPWR VGND sg13g2_decap_8
XFILLER_44_82 VPWR VGND sg13g2_decap_8
XFILLER_12_272 VPWR VGND sg13g2_decap_8
XFILLER_8_265 VPWR VGND sg13g2_decap_8
XFILLER_5_32 VPWR VGND sg13g2_decap_8
XFILLER_4_482 VPWR VGND sg13g2_decap_8
XFILLER_35_364 VPWR VGND sg13g2_decap_8
XFILLER_39_147 VPWR VGND sg13g2_decap_8
XFILLER_10_209 VPWR VGND sg13g2_decap_8
XFILLER_45_106 VPWR VGND sg13g2_decap_8
XFILLER_46_618 VPWR VGND sg13g2_fill_1
XFILLER_14_537 VPWR VGND sg13g2_decap_8
XFILLER_26_320 VPWR VGND sg13g2_decap_8
XFILLER_26_397 VPWR VGND sg13g2_decap_8
XFILLER_39_692 VPWR VGND sg13g2_decap_8
XFILLER_41_356 VPWR VGND sg13g2_decap_8
XFILLER_10_732 VPWR VGND sg13g2_fill_1
XFILLER_14_96 VPWR VGND sg13g2_decap_8
XFILLER_22_581 VPWR VGND sg13g2_decap_8
XFILLER_6_714 VPWR VGND sg13g2_fill_2
XFILLER_5_235 VPWR VGND sg13g2_decap_8
XFILLER_1_441 VPWR VGND sg13g2_decap_8
XFILLER_30_62 VPWR VGND sg13g2_decap_8
XFILLER_45_651 VPWR VGND sg13g2_fill_2
XFILLER_49_445 VPWR VGND sg13g2_decap_8
XFILLER_13_570 VPWR VGND sg13g2_decap_8
XFILLER_17_386 VPWR VGND sg13g2_decap_8
XFILLER_20_507 VPWR VGND sg13g2_decap_8
XFILLER_32_312 VPWR VGND sg13g2_decap_8
XFILLER_32_389 VPWR VGND sg13g2_decap_8
XFILLER_44_194 VPWR VGND sg13g2_decap_8
X_0972_ net103 VGND VPWR _0132_ state\[4\] clknet_5_12__leaf_clk sg13g2_dfrbpq_1
XFILLER_9_574 VPWR VGND sg13g2_decap_4
XFILLER_28_629 VPWR VGND sg13g2_decap_8
XFILLER_35_161 VPWR VGND sg13g2_decap_8
XFILLER_36_695 VPWR VGND sg13g2_decap_8
XFILLER_23_367 VPWR VGND sg13g2_decap_8
XFILLER_2_249 VPWR VGND sg13g2_decap_8
XFILLER_18_139 VPWR VGND sg13g2_decap_8
XFILLER_27_651 VPWR VGND sg13g2_decap_8
XFILLER_33_109 VPWR VGND sg13g2_decap_8
XFILLER_46_448 VPWR VGND sg13g2_decap_8
XFILLER_14_334 VPWR VGND sg13g2_decap_8
XFILLER_25_62 VPWR VGND sg13g2_decap_8
XFILLER_26_194 VPWR VGND sg13g2_decap_8
XFILLER_41_94 VPWR VGND sg13g2_decap_8
XFILLER_6_522 VPWR VGND sg13g2_decap_8
XFILLER_2_11 VPWR VGND sg13g2_decap_8
XFILLER_37_7 VPWR VGND sg13g2_decap_8
XFILLER_49_242 VPWR VGND sg13g2_decap_8
XFILLER_17_183 VPWR VGND sg13g2_decap_8
XFILLER_2_88 VPWR VGND sg13g2_decap_8
XFILLER_37_448 VPWR VGND sg13g2_decap_8
XFILLER_45_470 VPWR VGND sg13g2_decap_8
XFILLER_20_304 VPWR VGND sg13g2_decap_8
XFILLER_32_186 VPWR VGND sg13g2_decap_8
XFILLER_33_698 VPWR VGND sg13g2_decap_4
X_0886_ VPWR _0009_ state\[50\] VGND sg13g2_inv_1
X_0955_ net111 VGND VPWR _0115_ daisychain\[51\] clknet_5_30__leaf_clk sg13g2_dfrbpq_1
XFILLER_9_382 VPWR VGND sg13g2_decap_8
XFILLER_28_426 VPWR VGND sg13g2_decap_8
XFILLER_46_28 VPWR VGND sg13g2_decap_8
XFILLER_11_326 VPWR VGND sg13g2_decap_8
XFILLER_23_164 VPWR VGND sg13g2_decap_8
XFILLER_24_665 VPWR VGND sg13g2_decap_8
XFILLER_11_53 VPWR VGND sg13g2_decap_8
XFILLER_3_536 VPWR VGND sg13g2_decap_8
XFILLER_7_308 VPWR VGND sg13g2_decap_8
XFILLER_2_4 VPWR VGND sg13g2_decap_8
XFILLER_14_131 VPWR VGND sg13g2_decap_8
XFILLER_19_448 VPWR VGND sg13g2_decap_8
XFILLER_46_245 VPWR VGND sg13g2_decap_8
XFILLER_10_370 VPWR VGND sg13g2_decap_8
XFILLER_30_657 VPWR VGND sg13g2_decap_8
X_0740_ _0319_ VPWR _0148_ VGND net87 _0044_ sg13g2_o21ai_1
X_0671_ net90 VPWR _0414_ VGND net69 state\[52\] sg13g2_o21ai_1
XFILLER_6_396 VPWR VGND sg13g2_decap_8
XFILLER_37_245 VPWR VGND sg13g2_decap_8
XFILLER_20_101 VPWR VGND sg13g2_decap_8
XFILLER_33_473 VPWR VGND sg13g2_decap_8
XFILLER_20_178 VPWR VGND sg13g2_decap_8
XFILLER_21_668 VPWR VGND sg13g2_decap_8
X_0869_ VPWR _0234_ daisychain\[41\] VGND sg13g2_inv_1
X_0938_ net113 VGND VPWR _0098_ daisychain\[34\] clknet_5_19__leaf_clk sg13g2_dfrbpq_1
XFILLER_0_539 VPWR VGND sg13g2_decap_8
XFILLER_28_223 VPWR VGND sg13g2_decap_8
XFILLER_29_768 VPWR VGND sg13g2_fill_2
XFILLER_43_248 VPWR VGND sg13g2_decap_8
XFILLER_11_123 VPWR VGND sg13g2_decap_8
XFILLER_24_462 VPWR VGND sg13g2_decap_8
XFILLER_7_105 VPWR VGND sg13g2_decap_8
XFILLER_22_63 VPWR VGND sg13g2_decap_8
XFILLER_3_333 VPWR VGND sg13g2_decap_8
XFILLER_19_245 VPWR VGND sg13g2_decap_8
XFILLER_47_532 VPWR VGND sg13g2_decap_8
XFILLER_30_454 VPWR VGND sg13g2_decap_8
X_0723_ _0268_ VPWR _0131_ VGND net99 _0057_ sg13g2_o21ai_1
XFILLER_8_76 VPWR VGND sg13g2_decap_8
XFILLER_7_661 VPWR VGND sg13g2_fill_2
X_0654_ _0111_ _0400_ _0401_ net51 _0240_ VPWR VGND sg13g2_a22oi_1
X_0585_ VGND VPWR net25 daisychain\[29\] _0350_ net40 sg13g2_a21oi_1
XFILLER_6_193 VPWR VGND sg13g2_decap_8
XFILLER_25_237 VPWR VGND sg13g2_decap_8
XFILLER_26_705 VPWR VGND sg13g2_decap_8
XFILLER_38_532 VPWR VGND sg13g2_decap_8
XFILLER_21_465 VPWR VGND sg13g2_decap_8
XFILLER_33_270 VPWR VGND sg13g2_decap_8
XFILLER_5_609 VPWR VGND sg13g2_decap_4
XFILLER_0_336 VPWR VGND sg13g2_decap_8
XFILLER_48_329 VPWR VGND sg13g2_decap_8
XFILLER_12_410 VPWR VGND sg13g2_decap_8
XFILLER_17_85 VPWR VGND sg13g2_decap_8
XFILLER_31_218 VPWR VGND sg13g2_decap_8
XFILLER_12_487 VPWR VGND sg13g2_decap_8
XFILLER_33_95 VPWR VGND sg13g2_decap_8
XFILLER_8_447 VPWR VGND sg13g2_decap_8
XFILLER_3_130 VPWR VGND sg13g2_decap_8
XFILLER_4_675 VPWR VGND sg13g2_fill_2
XFILLER_35_546 VPWR VGND sg13g2_decap_8
XFILLER_39_329 VPWR VGND sg13g2_decap_8
XFILLER_16_771 VPWR VGND sg13g2_decap_4
XFILLER_30_251 VPWR VGND sg13g2_decap_8
XFILLER_31_796 VPWR VGND sg13g2_fill_2
Xclkbuf_4_4_0_clk clknet_0_clk clknet_4_4_0_clk VPWR VGND sg13g2_buf_8
X_0706_ _0124_ _0439_ _0440_ net36 _0253_ VPWR VGND sg13g2_a22oi_1
X_0637_ VGND VPWR net29 daisychain\[42\] _0389_ net50 sg13g2_a21oi_1
X_0568_ _0219_ net60 _0336_ _0337_ VPWR VGND sg13g2_a21o_1
X_0499_ net84 VPWR _0285_ VGND net63 state\[9\] sg13g2_o21ai_1
XFILLER_26_502 VPWR VGND sg13g2_decap_8
XFILLER_26_579 VPWR VGND sg13g2_decap_8
XFILLER_21_262 VPWR VGND sg13g2_decap_8
XFILLER_5_417 VPWR VGND sg13g2_decap_8
XFILLER_0_133 VPWR VGND sg13g2_decap_8
XFILLER_28_62 VPWR VGND sg13g2_decap_8
XFILLER_29_384 VPWR VGND sg13g2_decap_8
XFILLER_48_126 VPWR VGND sg13g2_decap_8
XFILLER_49_627 VPWR VGND sg13g2_fill_2
XFILLER_12_251 VPWR VGND sg13g2_decap_8
XFILLER_17_568 VPWR VGND sg13g2_decap_8
XFILLER_44_376 VPWR VGND sg13g2_decap_8
XFILLER_44_61 VPWR VGND sg13g2_decap_8
XFILLER_40_582 VPWR VGND sg13g2_decap_8
XFILLER_8_244 VPWR VGND sg13g2_decap_8
XFILLER_5_11 VPWR VGND sg13g2_decap_8
XFILLER_4_461 VPWR VGND sg13g2_decap_8
XFILLER_39_126 VPWR VGND sg13g2_decap_8
XFILLER_5_88 VPWR VGND sg13g2_decap_8
XFILLER_35_343 VPWR VGND sg13g2_decap_8
XFILLER_36_811 VPWR VGND sg13g2_decap_8
XFILLER_36_822 VPWR VGND sg13g2_fill_1
XFILLER_23_549 VPWR VGND sg13g2_decap_8
XFILLER_31_582 VPWR VGND sg13g2_decap_8
XFILLER_49_39 VPWR VGND sg13g2_decap_8
XFILLER_14_516 VPWR VGND sg13g2_decap_8
XFILLER_22_560 VPWR VGND sg13g2_decap_8
XFILLER_26_376 VPWR VGND sg13g2_decap_8
XFILLER_41_335 VPWR VGND sg13g2_decap_8
XFILLER_14_75 VPWR VGND sg13g2_decap_8
XFILLER_30_41 VPWR VGND sg13g2_decap_8
XFILLER_5_214 VPWR VGND sg13g2_decap_8
XFILLER_1_420 VPWR VGND sg13g2_decap_8
XFILLER_1_497 VPWR VGND sg13g2_decap_8
XFILLER_49_424 VPWR VGND sg13g2_decap_8
XFILLER_17_365 VPWR VGND sg13g2_decap_8
XFILLER_29_181 VPWR VGND sg13g2_decap_8
XFILLER_44_173 VPWR VGND sg13g2_decap_8
XFILLER_45_641 VPWR VGND sg13g2_fill_2
XFILLER_32_368 VPWR VGND sg13g2_decap_8
X_0971_ net102 VGND VPWR _0131_ state\[3\] clknet_5_9__leaf_clk sg13g2_dfrbpq_1
XFILLER_9_553 VPWR VGND sg13g2_decap_8
XFILLER_28_608 VPWR VGND sg13g2_decap_8
XFILLER_36_630 VPWR VGND sg13g2_decap_8
XFILLER_48_490 VPWR VGND sg13g2_decap_8
XFILLER_11_519 VPWR VGND sg13g2_decap_8
XFILLER_23_346 VPWR VGND sg13g2_decap_8
XFILLER_35_140 VPWR VGND sg13g2_decap_8
XFILLER_2_228 VPWR VGND sg13g2_decap_8
XFILLER_14_313 VPWR VGND sg13g2_decap_8
XFILLER_18_118 VPWR VGND sg13g2_decap_8
XFILLER_26_173 VPWR VGND sg13g2_decap_8
XFILLER_27_630 VPWR VGND sg13g2_decap_8
XFILLER_39_490 VPWR VGND sg13g2_decap_8
XFILLER_46_427 VPWR VGND sg13g2_decap_8
XFILLER_25_41 VPWR VGND sg13g2_decap_8
XFILLER_41_143 VPWR VGND sg13g2_decap_8
XFILLER_41_154 VPWR VGND sg13g2_fill_2
XFILLER_6_501 VPWR VGND sg13g2_decap_8
XFILLER_10_574 VPWR VGND sg13g2_decap_4
XFILLER_41_73 VPWR VGND sg13g2_decap_8
XFILLER_1_294 VPWR VGND sg13g2_decap_8
XFILLER_2_67 VPWR VGND sg13g2_decap_8
XFILLER_37_427 VPWR VGND sg13g2_decap_8
XFILLER_49_298 VPWR VGND sg13g2_decap_8
XFILLER_49_221 VPWR VGND sg13g2_decap_8
XFILLER_17_162 VPWR VGND sg13g2_decap_8
XFILLER_18_685 VPWR VGND sg13g2_fill_2
XFILLER_32_165 VPWR VGND sg13g2_decap_8
XFILLER_33_655 VPWR VGND sg13g2_decap_8
X_0885_ VPWR _0242_ daisychain\[49\] VGND sg13g2_inv_1
X_0954_ net111 VGND VPWR _0114_ daisychain\[50\] clknet_5_29__leaf_clk sg13g2_dfrbpq_1
XFILLER_9_361 VPWR VGND sg13g2_decap_8
XFILLER_28_405 VPWR VGND sg13g2_decap_8
XFILLER_11_305 VPWR VGND sg13g2_decap_8
XFILLER_23_143 VPWR VGND sg13g2_decap_8
XFILLER_24_644 VPWR VGND sg13g2_decap_8
XFILLER_11_32 VPWR VGND sg13g2_decap_8
XFILLER_3_515 VPWR VGND sg13g2_decap_8
XFILLER_19_427 VPWR VGND sg13g2_decap_8
XFILLER_46_224 VPWR VGND sg13g2_decap_8
XFILLER_14_110 VPWR VGND sg13g2_decap_8
XFILLER_15_611 VPWR VGND sg13g2_decap_8
XFILLER_15_622 VPWR VGND sg13g2_fill_2
XFILLER_15_633 VPWR VGND sg13g2_decap_8
XFILLER_36_84 VPWR VGND sg13g2_decap_8
XFILLER_42_441 VPWR VGND sg13g2_decap_8
XFILLER_42_452 VPWR VGND sg13g2_fill_1
XFILLER_14_187 VPWR VGND sg13g2_decap_8
XFILLER_30_636 VPWR VGND sg13g2_decap_8
XFILLER_42_485 VPWR VGND sg13g2_decap_8
X_0670_ _0115_ _0412_ _0413_ net52 _0244_ VPWR VGND sg13g2_a22oi_1
XFILLER_6_375 VPWR VGND sg13g2_decap_8
XFILLER_28_4 VPWR VGND sg13g2_decap_4
XFILLER_37_224 VPWR VGND sg13g2_decap_8
XFILLER_18_482 VPWR VGND sg13g2_decap_8
XFILLER_20_157 VPWR VGND sg13g2_decap_8
XFILLER_21_647 VPWR VGND sg13g2_decap_8
XFILLER_33_452 VPWR VGND sg13g2_decap_8
X_0868_ VPWR _0031_ state\[41\] VGND sg13g2_inv_1
X_0937_ net113 VGND VPWR _0097_ daisychain\[33\] clknet_5_19__leaf_clk sg13g2_dfrbpq_1
Xclkbuf_5_15__f_clk clknet_5_15__leaf_clk clknet_4_7_0_clk VPWR VGND sg13g2_buf_16
X_0799_ VPWR _0199_ daisychain\[6\] VGND sg13g2_inv_1
XFILLER_0_518 VPWR VGND sg13g2_decap_8
XFILLER_28_202 VPWR VGND sg13g2_decap_8
XFILLER_24_441 VPWR VGND sg13g2_decap_8
XFILLER_28_279 VPWR VGND sg13g2_decap_8
XFILLER_43_227 VPWR VGND sg13g2_decap_8
XFILLER_11_102 VPWR VGND sg13g2_decap_8
XFILLER_11_179 VPWR VGND sg13g2_decap_8
XFILLER_22_42 VPWR VGND sg13g2_decap_8
XFILLER_3_312 VPWR VGND sg13g2_decap_8
XFILLER_3_389 VPWR VGND sg13g2_decap_8
XFILLER_19_224 VPWR VGND sg13g2_decap_8
XFILLER_47_511 VPWR VGND sg13g2_decap_8
XFILLER_47_588 VPWR VGND sg13g2_decap_8
XFILLER_15_485 VPWR VGND sg13g2_decap_8
XFILLER_30_433 VPWR VGND sg13g2_decap_8
XFILLER_34_249 VPWR VGND sg13g2_decap_8
XFILLER_11_680 VPWR VGND sg13g2_decap_8
X_0722_ _0265_ VPWR _0130_ VGND net99 _0054_ sg13g2_o21ai_1
X_0653_ VGND VPWR net29 daisychain\[46\] _0401_ net51 sg13g2_a21oi_1
XFILLER_8_55 VPWR VGND sg13g2_decap_8
XFILLER_7_695 VPWR VGND sg13g2_fill_1
XFILLER_6_172 VPWR VGND sg13g2_decap_8
XFILLER_38_511 VPWR VGND sg13g2_decap_8
X_0584_ _0223_ net62 _0348_ _0349_ VPWR VGND sg13g2_a21o_1
XFILLER_19_780 VPWR VGND sg13g2_fill_2
XFILLER_25_216 VPWR VGND sg13g2_decap_8
XFILLER_38_588 VPWR VGND sg13g2_decap_8
XFILLER_21_444 VPWR VGND sg13g2_decap_8
XFILLER_0_315 VPWR VGND sg13g2_decap_8
XFILLER_29_500 VPWR VGND sg13g2_fill_2
XFILLER_29_555 VPWR VGND sg13g2_decap_4
XFILLER_48_308 VPWR VGND sg13g2_decap_8
XFILLER_16_249 VPWR VGND sg13g2_decap_8
XFILLER_17_64 VPWR VGND sg13g2_decap_8
XFILLER_12_466 VPWR VGND sg13g2_decap_8
XFILLER_33_74 VPWR VGND sg13g2_decap_8
XFILLER_8_426 VPWR VGND sg13g2_decap_8
XFILLER_39_308 VPWR VGND sg13g2_decap_8
XFILLER_3_186 VPWR VGND sg13g2_decap_8
XFILLER_35_525 VPWR VGND sg13g2_decap_8
XFILLER_47_385 VPWR VGND sg13g2_decap_8
XFILLER_15_282 VPWR VGND sg13g2_decap_8
XFILLER_30_230 VPWR VGND sg13g2_decap_8
X_0705_ VGND VPWR net34 daisychain\[59\] _0440_ net36 sg13g2_a21oi_1
X_0636_ _0236_ net72 _0387_ _0388_ VPWR VGND sg13g2_a21o_1
X_0567_ net82 VPWR _0336_ VGND net61 state\[26\] sg13g2_o21ai_1
X_0498_ _0072_ _0283_ _0284_ net38 _0201_ VPWR VGND sg13g2_a22oi_1
XFILLER_22_742 VPWR VGND sg13g2_decap_8
XFILLER_26_558 VPWR VGND sg13g2_decap_8
XFILLER_38_385 VPWR VGND sg13g2_decap_8
XFILLER_21_241 VPWR VGND sg13g2_decap_8
XFILLER_0_112 VPWR VGND sg13g2_decap_8
XFILLER_48_105 VPWR VGND sg13g2_decap_8
XFILLER_49_606 VPWR VGND sg13g2_decap_8
XFILLER_0_189 VPWR VGND sg13g2_decap_8
XFILLER_17_547 VPWR VGND sg13g2_decap_8
XFILLER_28_41 VPWR VGND sg13g2_decap_8
XFILLER_29_363 VPWR VGND sg13g2_decap_8
XFILLER_44_355 VPWR VGND sg13g2_decap_8
XFILLER_12_230 VPWR VGND sg13g2_decap_8
XFILLER_13_742 VPWR VGND sg13g2_fill_2
XFILLER_40_561 VPWR VGND sg13g2_decap_8
XFILLER_9_724 VPWR VGND sg13g2_decap_8
XFILLER_8_223 VPWR VGND sg13g2_decap_8
XFILLER_5_67 VPWR VGND sg13g2_decap_8
XFILLER_4_440 VPWR VGND sg13g2_decap_8
XFILLER_0_690 VPWR VGND sg13g2_fill_2
XFILLER_10_4 VPWR VGND sg13g2_decap_4
XFILLER_39_105 VPWR VGND sg13g2_decap_8
XFILLER_23_528 VPWR VGND sg13g2_decap_8
XFILLER_35_322 VPWR VGND sg13g2_decap_8
XFILLER_35_399 VPWR VGND sg13g2_decap_8
XFILLER_47_182 VPWR VGND sg13g2_decap_8
XFILLER_31_561 VPWR VGND sg13g2_decap_8
X_0619_ net96 VPWR _0375_ VGND net74 state\[39\] sg13g2_o21ai_1
XFILLER_49_18 VPWR VGND sg13g2_decap_8
XFILLER_26_355 VPWR VGND sg13g2_decap_8
XFILLER_27_812 VPWR VGND sg13g2_decap_8
XFILLER_38_182 VPWR VGND sg13g2_decap_8
XFILLER_46_609 VPWR VGND sg13g2_decap_8
XFILLER_14_54 VPWR VGND sg13g2_decap_8
XFILLER_41_314 VPWR VGND sg13g2_decap_8
XFILLER_30_97 VPWR VGND sg13g2_decap_8
XFILLER_1_476 VPWR VGND sg13g2_decap_8
XFILLER_37_609 VPWR VGND sg13g2_decap_8
XFILLER_39_84 VPWR VGND sg13g2_decap_8
Xclkbuf_4_3_0_clk clknet_0_clk clknet_4_3_0_clk VPWR VGND sg13g2_buf_8
XFILLER_49_403 VPWR VGND sg13g2_decap_8
XFILLER_17_344 VPWR VGND sg13g2_decap_8
XFILLER_29_160 VPWR VGND sg13g2_decap_8
XFILLER_32_347 VPWR VGND sg13g2_decap_8
XFILLER_36_119 VPWR VGND sg13g2_decap_8
XFILLER_44_152 VPWR VGND sg13g2_decap_8
XFILLER_40_391 VPWR VGND sg13g2_decap_8
X_0970_ net102 VGND VPWR _0130_ state\[2\] clknet_5_11__leaf_clk sg13g2_dfrbpq_1
XFILLER_27_119 VPWR VGND sg13g2_decap_8
XFILLER_36_664 VPWR VGND sg13g2_decap_8
XFILLER_23_325 VPWR VGND sg13g2_decap_8
XFILLER_35_196 VPWR VGND sg13g2_decap_8
XFILLER_36_675 VPWR VGND sg13g2_fill_1
XFILLER_2_207 VPWR VGND sg13g2_decap_8
XFILLER_19_609 VPWR VGND sg13g2_decap_8
XFILLER_46_406 VPWR VGND sg13g2_decap_8
XFILLER_26_152 VPWR VGND sg13g2_decap_8
XFILLER_27_686 VPWR VGND sg13g2_decap_8
XFILLER_41_122 VPWR VGND sg13g2_decap_8
XFILLER_42_645 VPWR VGND sg13g2_fill_2
XFILLER_10_553 VPWR VGND sg13g2_decap_8
XFILLER_14_369 VPWR VGND sg13g2_decap_8
XFILLER_25_97 VPWR VGND sg13g2_decap_8
XFILLER_30_807 VPWR VGND sg13g2_decap_8
XFILLER_41_188 VPWR VGND sg13g2_decap_8
XFILLER_41_52 VPWR VGND sg13g2_decap_8
XFILLER_10_597 VPWR VGND sg13g2_decap_8
XFILLER_2_752 VPWR VGND sg13g2_fill_2
XFILLER_1_273 VPWR VGND sg13g2_decap_8
XFILLER_2_46 VPWR VGND sg13g2_decap_8
XFILLER_37_406 VPWR VGND sg13g2_decap_8
XFILLER_49_277 VPWR VGND sg13g2_decap_8
XFILLER_49_200 VPWR VGND sg13g2_decap_8
XFILLER_17_141 VPWR VGND sg13g2_decap_8
XFILLER_18_664 VPWR VGND sg13g2_decap_8
XFILLER_20_339 VPWR VGND sg13g2_decap_8
XFILLER_21_818 VPWR VGND sg13g2_decap_4
XFILLER_32_144 VPWR VGND sg13g2_decap_8
XFILLER_33_634 VPWR VGND sg13g2_decap_8
X_0884_ VPWR _0008_ state\[49\] VGND sg13g2_inv_1
X_0953_ net116 VGND VPWR _0113_ daisychain\[49\] clknet_5_30__leaf_clk sg13g2_dfrbpq_1
XFILLER_9_340 VPWR VGND sg13g2_decap_8
XFILLER_23_122 VPWR VGND sg13g2_decap_8
XFILLER_24_623 VPWR VGND sg13g2_decap_8
XFILLER_36_483 VPWR VGND sg13g2_decap_8
XFILLER_43_409 VPWR VGND sg13g2_decap_8
XFILLER_23_199 VPWR VGND sg13g2_decap_8
XFILLER_11_11 VPWR VGND sg13g2_decap_8
XFILLER_11_88 VPWR VGND sg13g2_decap_8
XFILLER_19_406 VPWR VGND sg13g2_decap_8
XFILLER_46_203 VPWR VGND sg13g2_decap_8
XFILLER_14_166 VPWR VGND sg13g2_decap_8
XFILLER_27_483 VPWR VGND sg13g2_decap_8
XFILLER_30_615 VPWR VGND sg13g2_decap_8
XFILLER_36_63 VPWR VGND sg13g2_decap_8
XFILLER_42_420 VPWR VGND sg13g2_decap_8
XFILLER_6_354 VPWR VGND sg13g2_decap_8
XFILLER_42_7 VPWR VGND sg13g2_decap_8
XFILLER_18_461 VPWR VGND sg13g2_decap_8
XFILLER_37_203 VPWR VGND sg13g2_decap_8
XFILLER_20_136 VPWR VGND sg13g2_decap_8
XFILLER_21_626 VPWR VGND sg13g2_decap_8
XFILLER_33_431 VPWR VGND sg13g2_decap_8
X_0936_ net113 VGND VPWR _0096_ daisychain\[32\] clknet_5_18__leaf_clk sg13g2_dfrbpq_1
X_0867_ VPWR _0233_ daisychain\[40\] VGND sg13g2_inv_1
X_0798_ VPWR _0060_ state\[6\] VGND sg13g2_inv_1
XFILLER_29_726 VPWR VGND sg13g2_decap_8
XFILLER_24_420 VPWR VGND sg13g2_decap_8
XFILLER_24_497 VPWR VGND sg13g2_decap_8
XFILLER_28_258 VPWR VGND sg13g2_decap_8
XFILLER_36_280 VPWR VGND sg13g2_decap_8
XFILLER_43_206 VPWR VGND sg13g2_decap_8
XFILLER_44_729 VPWR VGND sg13g2_fill_2
XFILLER_11_158 VPWR VGND sg13g2_decap_8
XFILLER_12_648 VPWR VGND sg13g2_fill_2
XFILLER_22_98 VPWR VGND sg13g2_decap_8
XFILLER_3_368 VPWR VGND sg13g2_decap_8
XFILLER_19_203 VPWR VGND sg13g2_decap_8
XFILLER_27_280 VPWR VGND sg13g2_decap_8
XFILLER_34_228 VPWR VGND sg13g2_decap_8
XFILLER_47_567 VPWR VGND sg13g2_decap_8
XFILLER_47_84 VPWR VGND sg13g2_decap_8
XFILLER_15_464 VPWR VGND sg13g2_decap_8
XFILLER_30_412 VPWR VGND sg13g2_decap_8
XFILLER_30_489 VPWR VGND sg13g2_decap_8
XFILLER_42_294 VPWR VGND sg13g2_decap_8
Xclkbuf_5_21__f_clk clknet_5_21__leaf_clk clknet_4_10_0_clk VPWR VGND sg13g2_buf_16
XFILLER_8_34 VPWR VGND sg13g2_decap_8
X_0721_ _0262_ VPWR _0129_ VGND net99 _0043_ sg13g2_o21ai_1
X_0652_ _0240_ net75 _0399_ _0400_ VPWR VGND sg13g2_a21o_1
X_0583_ net88 VPWR _0348_ VGND net67 state\[30\] sg13g2_o21ai_1
XFILLER_7_663 VPWR VGND sg13g2_fill_1
XFILLER_6_151 VPWR VGND sg13g2_decap_8
XFILLER_38_567 VPWR VGND sg13g2_decap_8
XFILLER_40_209 VPWR VGND sg13g2_decap_8
XFILLER_21_423 VPWR VGND sg13g2_decap_8
X_0919_ net110 VGND VPWR _0079_ daisychain\[15\] clknet_5_5__leaf_clk sg13g2_dfrbpq_1
XFILLER_16_228 VPWR VGND sg13g2_decap_8
XFILLER_29_534 VPWR VGND sg13g2_decap_8
XFILLER_44_515 VPWR VGND sg13g2_decap_8
XFILLER_44_526 VPWR VGND sg13g2_fill_2
XFILLER_12_445 VPWR VGND sg13g2_decap_8
XFILLER_24_294 VPWR VGND sg13g2_decap_8
XFILLER_25_784 VPWR VGND sg13g2_fill_1
XFILLER_33_53 VPWR VGND sg13g2_decap_8
XFILLER_8_405 VPWR VGND sg13g2_decap_8
XFILLER_4_677 VPWR VGND sg13g2_fill_1
XFILLER_12_8 VPWR VGND sg13g2_fill_1
XFILLER_3_165 VPWR VGND sg13g2_decap_8
XFILLER_48_821 VPWR VGND sg13g2_fill_2
XFILLER_15_261 VPWR VGND sg13g2_decap_8
XFILLER_31_721 VPWR VGND sg13g2_fill_2
XFILLER_35_504 VPWR VGND sg13g2_decap_8
XFILLER_47_364 VPWR VGND sg13g2_decap_8
XFILLER_30_286 VPWR VGND sg13g2_decap_8
XFILLER_31_798 VPWR VGND sg13g2_fill_1
X_0704_ _0253_ net58 _0438_ _0439_ VPWR VGND sg13g2_a21o_1
X_0635_ net94 VPWR _0387_ VGND net72 state\[43\] sg13g2_o21ai_1
X_0566_ _0089_ _0334_ _0335_ net38 _0218_ VPWR VGND sg13g2_a22oi_1
XFILLER_26_537 VPWR VGND sg13g2_decap_8
XFILLER_38_364 VPWR VGND sg13g2_decap_8
X_0497_ VGND VPWR net24 daisychain\[7\] _0284_ net38 sg13g2_a21oi_1
XFILLER_13_209 VPWR VGND sg13g2_decap_8
XFILLER_21_220 VPWR VGND sg13g2_decap_8
XFILLER_22_721 VPWR VGND sg13g2_decap_8
XFILLER_34_592 VPWR VGND sg13g2_decap_8
XFILLER_41_529 VPWR VGND sg13g2_decap_8
X_1049_ daisychain\[57\] net17 VPWR VGND sg13g2_buf_1
XFILLER_21_297 VPWR VGND sg13g2_decap_8
XFILLER_0_168 VPWR VGND sg13g2_decap_8
XFILLER_28_20 VPWR VGND sg13g2_decap_8
XFILLER_17_526 VPWR VGND sg13g2_decap_8
XFILLER_28_97 VPWR VGND sg13g2_decap_8
XFILLER_29_342 VPWR VGND sg13g2_decap_8
XFILLER_32_529 VPWR VGND sg13g2_decap_8
XFILLER_44_334 VPWR VGND sg13g2_decap_8
XFILLER_12_286 VPWR VGND sg13g2_decap_8
XFILLER_25_592 VPWR VGND sg13g2_decap_8
XFILLER_40_540 VPWR VGND sg13g2_decap_8
XFILLER_44_96 VPWR VGND sg13g2_decap_8
XFILLER_8_279 VPWR VGND sg13g2_decap_8
XFILLER_8_202 VPWR VGND sg13g2_decap_8
XFILLER_5_46 VPWR VGND sg13g2_decap_8
XFILLER_4_496 VPWR VGND sg13g2_decap_8
XFILLER_35_301 VPWR VGND sg13g2_decap_8
XFILLER_47_161 VPWR VGND sg13g2_decap_8
XFILLER_16_592 VPWR VGND sg13g2_decap_8
XFILLER_23_507 VPWR VGND sg13g2_decap_8
XFILLER_31_540 VPWR VGND sg13g2_decap_8
XFILLER_35_378 VPWR VGND sg13g2_decap_8
X_0618_ _0102_ _0373_ _0374_ net52 _0231_ VPWR VGND sg13g2_a22oi_1
X_0549_ VGND VPWR net27 daisychain\[20\] _0323_ net44 sg13g2_a21oi_1
XFILLER_26_334 VPWR VGND sg13g2_decap_8
XFILLER_27_802 VPWR VGND sg13g2_fill_1
XFILLER_38_161 VPWR VGND sg13g2_decap_8
XFILLER_14_33 VPWR VGND sg13g2_decap_8
XFILLER_22_595 VPWR VGND sg13g2_decap_8
XFILLER_30_76 VPWR VGND sg13g2_decap_8
XFILLER_5_249 VPWR VGND sg13g2_decap_8
XFILLER_1_455 VPWR VGND sg13g2_decap_8
XFILLER_39_63 VPWR VGND sg13g2_decap_8
XFILLER_49_459 VPWR VGND sg13g2_decap_8
XFILLER_17_323 VPWR VGND sg13g2_decap_8
XFILLER_32_326 VPWR VGND sg13g2_decap_8
XFILLER_33_816 VPWR VGND sg13g2_decap_8
XFILLER_44_131 VPWR VGND sg13g2_decap_8
XFILLER_13_584 VPWR VGND sg13g2_decap_8
XFILLER_40_370 VPWR VGND sg13g2_decap_8
XFILLER_4_293 VPWR VGND sg13g2_decap_8
XFILLER_23_304 VPWR VGND sg13g2_decap_8
XFILLER_35_175 VPWR VGND sg13g2_decap_8
XFILLER_14_348 VPWR VGND sg13g2_decap_8
XFILLER_15_805 VPWR VGND sg13g2_fill_2
XFILLER_25_76 VPWR VGND sg13g2_decap_8
XFILLER_26_131 VPWR VGND sg13g2_decap_8
XFILLER_27_665 VPWR VGND sg13g2_decap_8
XFILLER_41_101 VPWR VGND sg13g2_decap_8
Xclkbuf_5_2__f_clk clknet_5_2__leaf_clk clknet_4_1_0_clk VPWR VGND sg13g2_buf_16
XFILLER_10_510 VPWR VGND sg13g2_decap_8
XFILLER_22_392 VPWR VGND sg13g2_decap_8
XFILLER_41_31 VPWR VGND sg13g2_decap_8
XFILLER_6_536 VPWR VGND sg13g2_decap_8
XFILLER_1_252 VPWR VGND sg13g2_decap_8
XFILLER_2_25 VPWR VGND sg13g2_decap_8
XFILLER_17_120 VPWR VGND sg13g2_decap_8
XFILLER_18_643 VPWR VGND sg13g2_decap_8
XFILLER_18_687 VPWR VGND sg13g2_fill_1
XFILLER_33_613 VPWR VGND sg13g2_decap_8
XFILLER_49_256 VPWR VGND sg13g2_decap_8
XFILLER_13_370 VPWR VGND sg13g2_decap_8
XFILLER_17_197 VPWR VGND sg13g2_decap_8
XFILLER_20_318 VPWR VGND sg13g2_decap_8
XFILLER_32_123 VPWR VGND sg13g2_decap_8
XFILLER_45_484 VPWR VGND sg13g2_decap_8
X_0952_ net116 VGND VPWR _0112_ daisychain\[48\] clknet_5_31__leaf_clk sg13g2_dfrbpq_1
X_0883_ VPWR _0241_ daisychain\[48\] VGND sg13g2_inv_1
XFILLER_9_396 VPWR VGND sg13g2_decap_8
XFILLER_5_591 VPWR VGND sg13g2_decap_8
XFILLER_23_101 VPWR VGND sg13g2_decap_8
XFILLER_24_602 VPWR VGND sg13g2_decap_8
XFILLER_24_679 VPWR VGND sg13g2_decap_8
XFILLER_36_462 VPWR VGND sg13g2_decap_8
XFILLER_23_178 VPWR VGND sg13g2_decap_8
XFILLER_32_690 VPWR VGND sg13g2_fill_2
Xclkbuf_4_2_0_clk clknet_0_clk clknet_4_2_0_clk VPWR VGND sg13g2_buf_8
XFILLER_11_67 VPWR VGND sg13g2_decap_8
XFILLER_27_462 VPWR VGND sg13g2_decap_8
XFILLER_36_42 VPWR VGND sg13g2_decap_8
XFILLER_46_259 VPWR VGND sg13g2_decap_8
XFILLER_47_705 VPWR VGND sg13g2_fill_2
XFILLER_14_145 VPWR VGND sg13g2_decap_8
XFILLER_10_384 VPWR VGND sg13g2_decap_8
XFILLER_6_333 VPWR VGND sg13g2_decap_8
XFILLER_2_550 VPWR VGND sg13g2_decap_8
XFILLER_35_7 VPWR VGND sg13g2_decap_8
XFILLER_38_738 VPWR VGND sg13g2_fill_2
XFILLER_18_440 VPWR VGND sg13g2_decap_8
XFILLER_33_410 VPWR VGND sg13g2_decap_8
XFILLER_37_259 VPWR VGND sg13g2_decap_8
XFILLER_45_281 VPWR VGND sg13g2_decap_8
XFILLER_20_115 VPWR VGND sg13g2_decap_8
XFILLER_21_605 VPWR VGND sg13g2_decap_8
XFILLER_33_487 VPWR VGND sg13g2_decap_8
X_0866_ VPWR _0030_ state\[40\] VGND sg13g2_inv_1
X_0935_ net106 VGND VPWR _0095_ daisychain\[31\] clknet_5_17__leaf_clk sg13g2_dfrbpq_1
XFILLER_9_193 VPWR VGND sg13g2_decap_8
X_0797_ VPWR _0198_ daisychain\[5\] VGND sg13g2_inv_1
XFILLER_28_237 VPWR VGND sg13g2_decap_8
XFILLER_29_705 VPWR VGND sg13g2_decap_8
XFILLER_11_137 VPWR VGND sg13g2_decap_8
XFILLER_24_476 VPWR VGND sg13g2_decap_8
XFILLER_20_682 VPWR VGND sg13g2_decap_8
XFILLER_22_77 VPWR VGND sg13g2_decap_8
XFILLER_7_119 VPWR VGND sg13g2_decap_8
XFILLER_3_347 VPWR VGND sg13g2_decap_8
XFILLER_15_443 VPWR VGND sg13g2_decap_8
XFILLER_19_259 VPWR VGND sg13g2_decap_8
XFILLER_28_782 VPWR VGND sg13g2_decap_4
XFILLER_28_793 VPWR VGND sg13g2_fill_2
XFILLER_34_207 VPWR VGND sg13g2_decap_8
XFILLER_47_546 VPWR VGND sg13g2_decap_8
XFILLER_47_63 VPWR VGND sg13g2_decap_8
XFILLER_30_468 VPWR VGND sg13g2_decap_8
XFILLER_42_273 VPWR VGND sg13g2_decap_8
X_0720_ _0258_ VPWR _0128_ VGND net82 _0032_ sg13g2_o21ai_1
XFILLER_8_13 VPWR VGND sg13g2_decap_8
XFILLER_10_181 VPWR VGND sg13g2_decap_8
X_0651_ net97 VPWR _0399_ VGND net75 state\[47\] sg13g2_o21ai_1
X_0582_ _0093_ _0346_ _0347_ net40 _0222_ VPWR VGND sg13g2_a22oi_1
XFILLER_7_686 VPWR VGND sg13g2_fill_2
XFILLER_6_130 VPWR VGND sg13g2_decap_8
XFILLER_26_719 VPWR VGND sg13g2_decap_8
XFILLER_33_4 VPWR VGND sg13g2_decap_8
XFILLER_38_546 VPWR VGND sg13g2_decap_8
XFILLER_21_402 VPWR VGND sg13g2_decap_8
XFILLER_33_284 VPWR VGND sg13g2_decap_8
XFILLER_34_741 VPWR VGND sg13g2_fill_1
XFILLER_34_796 VPWR VGND sg13g2_fill_2
XFILLER_21_479 VPWR VGND sg13g2_decap_8
X_0918_ net107 VGND VPWR _0078_ daisychain\[14\] clknet_5_5__leaf_clk sg13g2_dfrbpq_1
X_0849_ VPWR _0224_ daisychain\[31\] VGND sg13g2_inv_1
XFILLER_16_207 VPWR VGND sg13g2_decap_8
XFILLER_17_99 VPWR VGND sg13g2_decap_8
XFILLER_12_424 VPWR VGND sg13g2_decap_8
XFILLER_24_273 VPWR VGND sg13g2_decap_8
XFILLER_33_32 VPWR VGND sg13g2_decap_8
XFILLER_40_733 VPWR VGND sg13g2_decap_4
XFILLER_3_144 VPWR VGND sg13g2_decap_8
XFILLER_4_689 VPWR VGND sg13g2_fill_2
XFILLER_4_634 VPWR VGND sg13g2_fill_2
XFILLER_47_343 VPWR VGND sg13g2_decap_8
XFILLER_15_240 VPWR VGND sg13g2_decap_8
XFILLER_31_711 VPWR VGND sg13g2_fill_1
XFILLER_43_582 VPWR VGND sg13g2_decap_8
XFILLER_30_265 VPWR VGND sg13g2_decap_8
X_0703_ net79 VPWR _0438_ VGND net58 state\[60\] sg13g2_o21ai_1
XFILLER_7_483 VPWR VGND sg13g2_decap_8
X_0634_ _0106_ _0385_ _0386_ net50 _0235_ VPWR VGND sg13g2_a22oi_1
X_0565_ VGND VPWR net27 daisychain\[24\] _0335_ net41 sg13g2_a21oi_1
X_0496_ _0201_ net60 _0282_ _0283_ VPWR VGND sg13g2_a21o_1
XFILLER_26_516 VPWR VGND sg13g2_decap_8
XFILLER_38_343 VPWR VGND sg13g2_decap_8
XFILLER_0_91 VPWR VGND sg13g2_decap_8
XFILLER_21_276 VPWR VGND sg13g2_decap_8
XFILLER_22_777 VPWR VGND sg13g2_decap_4
XFILLER_34_571 VPWR VGND sg13g2_decap_8
X_1048_ daisychain\[56\] net16 VPWR VGND sg13g2_buf_1
XFILLER_0_147 VPWR VGND sg13g2_decap_8
XFILLER_29_321 VPWR VGND sg13g2_decap_8
XFILLER_17_505 VPWR VGND sg13g2_decap_8
XFILLER_25_571 VPWR VGND sg13g2_decap_8
XFILLER_28_76 VPWR VGND sg13g2_decap_8
XFILLER_29_398 VPWR VGND sg13g2_decap_8
XFILLER_32_508 VPWR VGND sg13g2_decap_8
XFILLER_44_313 VPWR VGND sg13g2_decap_8
XFILLER_44_75 VPWR VGND sg13g2_decap_8
XFILLER_12_265 VPWR VGND sg13g2_decap_8
XFILLER_40_596 VPWR VGND sg13g2_fill_2
XFILLER_8_258 VPWR VGND sg13g2_decap_8
XFILLER_5_25 VPWR VGND sg13g2_decap_8
XFILLER_4_475 VPWR VGND sg13g2_decap_8
XFILLER_0_670 VPWR VGND sg13g2_decap_8
XFILLER_47_140 VPWR VGND sg13g2_decap_8
XFILLER_16_571 VPWR VGND sg13g2_decap_8
XFILLER_31_596 VPWR VGND sg13g2_decap_8
XFILLER_35_357 VPWR VGND sg13g2_decap_8
XFILLER_7_280 VPWR VGND sg13g2_decap_8
X_0617_ VGND VPWR net28 daisychain\[37\] _0374_ net47 sg13g2_a21oi_1
X_0548_ _0214_ net66 _0321_ _0322_ VPWR VGND sg13g2_a21o_1
X_0479_ net81 VPWR _0270_ VGND net59 state\[4\] sg13g2_o21ai_1
XFILLER_26_313 VPWR VGND sg13g2_decap_8
XFILLER_38_140 VPWR VGND sg13g2_decap_8
XFILLER_39_674 VPWR VGND sg13g2_fill_2
XFILLER_41_349 VPWR VGND sg13g2_decap_8
XFILLER_10_736 VPWR VGND sg13g2_fill_2
XFILLER_14_89 VPWR VGND sg13g2_decap_8
XFILLER_22_574 VPWR VGND sg13g2_decap_8
XFILLER_5_228 VPWR VGND sg13g2_decap_8
XFILLER_1_434 VPWR VGND sg13g2_decap_8
XFILLER_30_55 VPWR VGND sg13g2_decap_8
XFILLER_39_42 VPWR VGND sg13g2_decap_8
XFILLER_17_302 VPWR VGND sg13g2_decap_8
XFILLER_29_195 VPWR VGND sg13g2_decap_8
XFILLER_44_110 VPWR VGND sg13g2_decap_8
XFILLER_49_438 VPWR VGND sg13g2_decap_8
XFILLER_13_563 VPWR VGND sg13g2_decap_8
XFILLER_17_379 VPWR VGND sg13g2_decap_8
XFILLER_32_305 VPWR VGND sg13g2_decap_8
XFILLER_44_187 VPWR VGND sg13g2_decap_8
XFILLER_45_666 VPWR VGND sg13g2_decap_4
XFILLER_9_501 VPWR VGND sg13g2_decap_8
XFILLER_9_578 VPWR VGND sg13g2_fill_1
XFILLER_9_567 VPWR VGND sg13g2_decap_8
XFILLER_4_272 VPWR VGND sg13g2_decap_8
XFILLER_24_817 VPWR VGND sg13g2_decap_4
XFILLER_35_154 VPWR VGND sg13g2_decap_8
XFILLER_36_644 VPWR VGND sg13g2_fill_2
XFILLER_36_688 VPWR VGND sg13g2_decap_8
XFILLER_31_393 VPWR VGND sg13g2_decap_8
XFILLER_26_110 VPWR VGND sg13g2_decap_8
XFILLER_27_644 VPWR VGND sg13g2_decap_8
XFILLER_14_327 VPWR VGND sg13g2_decap_8
XFILLER_15_817 VPWR VGND sg13g2_decap_4
XFILLER_22_371 VPWR VGND sg13g2_decap_8
XFILLER_25_55 VPWR VGND sg13g2_decap_8
XFILLER_26_187 VPWR VGND sg13g2_decap_8
XFILLER_41_87 VPWR VGND sg13g2_decap_8
XFILLER_6_515 VPWR VGND sg13g2_decap_8
XFILLER_1_231 VPWR VGND sg13g2_decap_8
XFILLER_2_732 VPWR VGND sg13g2_fill_1
XFILLER_49_235 VPWR VGND sg13g2_decap_8
XFILLER_17_176 VPWR VGND sg13g2_decap_8
XFILLER_18_622 VPWR VGND sg13g2_decap_8
XFILLER_32_102 VPWR VGND sg13g2_decap_8
XFILLER_45_463 VPWR VGND sg13g2_decap_8
XFILLER_32_179 VPWR VGND sg13g2_decap_8
X_0882_ VPWR _0007_ state\[48\] VGND sg13g2_inv_1
X_0951_ net114 VGND VPWR _0111_ daisychain\[47\] clknet_5_22__leaf_clk sg13g2_dfrbpq_1
XFILLER_9_375 VPWR VGND sg13g2_decap_8
XFILLER_28_419 VPWR VGND sg13g2_decap_8
XFILLER_49_780 VPWR VGND sg13g2_decap_4
XFILLER_11_319 VPWR VGND sg13g2_decap_8
XFILLER_23_157 VPWR VGND sg13g2_decap_8
XFILLER_24_658 VPWR VGND sg13g2_decap_8
XFILLER_36_441 VPWR VGND sg13g2_decap_8
XFILLER_11_46 VPWR VGND sg13g2_decap_8
XFILLER_20_820 VPWR VGND sg13g2_fill_2
XFILLER_31_190 VPWR VGND sg13g2_decap_8
XFILLER_3_529 VPWR VGND sg13g2_decap_8
XFILLER_27_441 VPWR VGND sg13g2_decap_8
XFILLER_36_21 VPWR VGND sg13g2_decap_8
XFILLER_46_238 VPWR VGND sg13g2_decap_8
XFILLER_14_124 VPWR VGND sg13g2_decap_8
XFILLER_36_98 VPWR VGND sg13g2_decap_8
XFILLER_42_499 VPWR VGND sg13g2_decap_4
XFILLER_10_363 VPWR VGND sg13g2_decap_8
XFILLER_6_389 VPWR VGND sg13g2_decap_8
XFILLER_6_312 VPWR VGND sg13g2_decap_8
XFILLER_37_238 VPWR VGND sg13g2_decap_8
XFILLER_18_496 VPWR VGND sg13g2_decap_8
XFILLER_33_466 VPWR VGND sg13g2_decap_8
XFILLER_45_260 VPWR VGND sg13g2_decap_8
X_0865_ VPWR _0232_ daisychain\[39\] VGND sg13g2_inv_1
X_0934_ net106 VGND VPWR _0094_ daisychain\[30\] clknet_5_2__leaf_clk sg13g2_dfrbpq_1
XFILLER_9_172 VPWR VGND sg13g2_decap_8
X_0796_ VPWR _0059_ state\[5\] VGND sg13g2_inv_1
XFILLER_28_216 VPWR VGND sg13g2_decap_8
XFILLER_11_116 VPWR VGND sg13g2_decap_8
XFILLER_12_606 VPWR VGND sg13g2_fill_2
XFILLER_20_661 VPWR VGND sg13g2_decap_8
XFILLER_24_455 VPWR VGND sg13g2_decap_8
XFILLER_22_56 VPWR VGND sg13g2_decap_8
XFILLER_3_326 VPWR VGND sg13g2_decap_8
XFILLER_19_238 VPWR VGND sg13g2_decap_8
XFILLER_47_42 VPWR VGND sg13g2_decap_8
XFILLER_47_525 VPWR VGND sg13g2_decap_8
XFILLER_15_422 VPWR VGND sg13g2_decap_8
XFILLER_28_761 VPWR VGND sg13g2_decap_8
XFILLER_42_252 VPWR VGND sg13g2_decap_8
XFILLER_10_160 VPWR VGND sg13g2_decap_8
XFILLER_15_499 VPWR VGND sg13g2_decap_8
XFILLER_30_447 VPWR VGND sg13g2_decap_8
XFILLER_8_69 VPWR VGND sg13g2_decap_8
XFILLER_7_654 VPWR VGND sg13g2_fill_2
Xdac0 digitalen0.g\[1\].u.OUTP digitalen0.g\[1\].u.OUTN digitalen0.g\[2\].u.OUTP digitalen0.g\[2\].u.OUTN
+ state\[16\] _0039_ state\[17\] _0040_ state\[18\] _0041_ state\[19\] _0042_ state\[20\]
+ _0044_ state\[21\] _0045_ state\[22\] _0046_ state\[23\] _0047_ state\[24\] _0048_
+ state\[25\] _0049_ state\[26\] _0050_ state\[27\] _0051_ state\[28\] _0052_ state\[29\]
+ _0053_ state\[30\] _0055_ state\[31\] _0056_ digitalen0.g\[3\].u.OUTP digitalen0.g\[3\].u.OUTN
+ state\[0\] _0032_ state\[1\] _0043_ state\[2\] _0054_ state\[3\] _0057_ state\[4\]
+ _0058_ state\[5\] _0059_ state\[6\] digitalen0.g\[0\].u.OUTP digitalen0.g\[0\].u.OUTN
+ _0060_ state\[7\] _0061_ state\[8\] _0062_ state\[9\] _0063_ state\[10\] _0033_
+ state\[11\] _0034_ state\[12\] _0035_ state\[13\] _0036_ state\[14\] _0037_ state\[15\]
+ _0038_ dac0/Iout dac0/VbiasP[0] dac0/VbiasP[1] dac0/VcascP[1] dac0/VcascP[0] VPWR
+ VGND dac32module
X_0650_ _0110_ _0397_ _0398_ net54 _0239_ VPWR VGND sg13g2_a22oi_1
X_0581_ VGND VPWR net25 daisychain\[28\] _0347_ net40 sg13g2_a21oi_1
XFILLER_6_186 VPWR VGND sg13g2_decap_8
XFILLER_26_4 VPWR VGND sg13g2_decap_8
XFILLER_38_525 VPWR VGND sg13g2_decap_8
Xclkbuf_4_1_0_clk clknet_0_clk clknet_4_1_0_clk VPWR VGND sg13g2_buf_8
XFILLER_18_293 VPWR VGND sg13g2_decap_8
XFILLER_21_458 VPWR VGND sg13g2_decap_8
XFILLER_33_263 VPWR VGND sg13g2_decap_8
X_0917_ net107 VGND VPWR _0077_ daisychain\[13\] clknet_5_7__leaf_clk sg13g2_dfrbpq_1
X_0848_ VPWR _0056_ state\[31\] VGND sg13g2_inv_1
X_0779_ _0436_ VPWR _0187_ VGND net79 _0019_ sg13g2_o21ai_1
XFILLER_0_329 VPWR VGND sg13g2_decap_8
XFILLER_17_78 VPWR VGND sg13g2_decap_8
XFILLER_24_252 VPWR VGND sg13g2_decap_8
XFILLER_33_11 VPWR VGND sg13g2_decap_8
XFILLER_33_88 VPWR VGND sg13g2_decap_8
XFILLER_3_123 VPWR VGND sg13g2_decap_8
XFILLER_4_668 VPWR VGND sg13g2_decap_8
XFILLER_4_646 VPWR VGND sg13g2_fill_1
XFILLER_35_539 VPWR VGND sg13g2_decap_8
XFILLER_47_322 VPWR VGND sg13g2_decap_8
XFILLER_48_812 VPWR VGND sg13g2_fill_2
XFILLER_15_296 VPWR VGND sg13g2_decap_8
XFILLER_16_764 VPWR VGND sg13g2_decap_8
XFILLER_16_775 VPWR VGND sg13g2_fill_2
XFILLER_28_580 VPWR VGND sg13g2_decap_8
XFILLER_30_244 VPWR VGND sg13g2_decap_8
XFILLER_43_561 VPWR VGND sg13g2_decap_8
XFILLER_47_399 VPWR VGND sg13g2_decap_8
XFILLER_11_491 VPWR VGND sg13g2_decap_8
X_0702_ _0123_ _0436_ _0437_ net36 _0252_ VPWR VGND sg13g2_a22oi_1
X_0633_ VGND VPWR net29 daisychain\[41\] _0386_ net51 sg13g2_a21oi_1
XFILLER_7_462 VPWR VGND sg13g2_decap_8
XFILLER_38_322 VPWR VGND sg13g2_decap_8
X_0564_ _0218_ net61 _0333_ _0334_ VPWR VGND sg13g2_a21o_1
X_0495_ net82 VPWR _0282_ VGND net60 state\[8\] sg13g2_o21ai_1
XFILLER_0_70 VPWR VGND sg13g2_decap_8
XFILLER_17_0 VPWR VGND sg13g2_decap_4
XFILLER_34_550 VPWR VGND sg13g2_decap_8
XFILLER_38_399 VPWR VGND sg13g2_decap_8
X_1047_ state\[63\] net15 VPWR VGND sg13g2_buf_1
XFILLER_21_255 VPWR VGND sg13g2_decap_8
XFILLER_0_126 VPWR VGND sg13g2_decap_8
XFILLER_28_55 VPWR VGND sg13g2_decap_8
XFILLER_29_300 VPWR VGND sg13g2_decap_8
XFILLER_29_377 VPWR VGND sg13g2_decap_8
XFILLER_48_119 VPWR VGND sg13g2_decap_8
XFILLER_12_244 VPWR VGND sg13g2_decap_8
XFILLER_25_550 VPWR VGND sg13g2_decap_8
XFILLER_44_21 VPWR VGND sg13g2_fill_1
XFILLER_44_369 VPWR VGND sg13g2_decap_8
XFILLER_44_54 VPWR VGND sg13g2_decap_8
XFILLER_40_575 VPWR VGND sg13g2_decap_8
XFILLER_9_738 VPWR VGND sg13g2_fill_2
XFILLER_8_237 VPWR VGND sg13g2_decap_8
XFILLER_39_119 VPWR VGND sg13g2_decap_8
XFILLER_4_454 VPWR VGND sg13g2_decap_8
XFILLER_16_550 VPWR VGND sg13g2_decap_8
XFILLER_35_336 VPWR VGND sg13g2_decap_8
XFILLER_36_804 VPWR VGND sg13g2_fill_1
XFILLER_47_196 VPWR VGND sg13g2_decap_8
XFILLER_31_575 VPWR VGND sg13g2_decap_8
X_0616_ _0231_ net74 _0372_ _0373_ VPWR VGND sg13g2_a21o_1
XFILLER_39_686 VPWR VGND sg13g2_fill_2
X_0547_ net86 VPWR _0321_ VGND net66 state\[21\] sg13g2_o21ai_1
X_0478_ _0067_ _0268_ _0269_ net37 _0196_ VPWR VGND sg13g2_a22oi_1
XFILLER_14_509 VPWR VGND sg13g2_decap_8
XFILLER_22_553 VPWR VGND sg13g2_decap_8
XFILLER_26_369 VPWR VGND sg13g2_decap_8
XFILLER_38_196 VPWR VGND sg13g2_decap_8
XFILLER_41_328 VPWR VGND sg13g2_decap_8
XFILLER_14_68 VPWR VGND sg13g2_decap_8
XFILLER_30_34 VPWR VGND sg13g2_decap_8
XFILLER_5_207 VPWR VGND sg13g2_decap_8
XFILLER_1_413 VPWR VGND sg13g2_decap_8
XFILLER_49_417 VPWR VGND sg13g2_decap_8
XFILLER_17_358 VPWR VGND sg13g2_decap_8
XFILLER_29_174 VPWR VGND sg13g2_decap_8
XFILLER_39_98 VPWR VGND sg13g2_decap_8
XFILLER_13_542 VPWR VGND sg13g2_decap_8
XFILLER_25_391 VPWR VGND sg13g2_decap_8
XFILLER_44_166 VPWR VGND sg13g2_decap_8
XFILLER_9_546 VPWR VGND sg13g2_decap_8
XFILLER_4_251 VPWR VGND sg13g2_decap_8
XFILLER_0_490 VPWR VGND sg13g2_decap_8
Xclkbuf_5_27__f_clk clknet_5_27__leaf_clk clknet_4_13_0_clk VPWR VGND sg13g2_buf_16
XFILLER_23_339 VPWR VGND sg13g2_decap_8
XFILLER_35_133 VPWR VGND sg13g2_decap_8
XFILLER_36_623 VPWR VGND sg13g2_decap_8
XFILLER_36_656 VPWR VGND sg13g2_fill_2
XFILLER_48_483 VPWR VGND sg13g2_decap_8
XFILLER_31_372 VPWR VGND sg13g2_decap_8
XFILLER_27_623 VPWR VGND sg13g2_decap_8
XFILLER_39_483 VPWR VGND sg13g2_decap_8
XFILLER_14_306 VPWR VGND sg13g2_decap_8
XFILLER_22_350 VPWR VGND sg13g2_decap_8
XFILLER_25_34 VPWR VGND sg13g2_decap_8
XFILLER_26_166 VPWR VGND sg13g2_decap_8
XFILLER_41_136 VPWR VGND sg13g2_decap_8
XFILLER_42_615 VPWR VGND sg13g2_fill_2
XFILLER_10_567 VPWR VGND sg13g2_decap_8
XFILLER_1_210 VPWR VGND sg13g2_decap_8
XFILLER_41_66 VPWR VGND sg13g2_decap_8
XFILLER_18_601 VPWR VGND sg13g2_decap_8
XFILLER_1_287 VPWR VGND sg13g2_decap_8
XFILLER_49_214 VPWR VGND sg13g2_decap_8
XFILLER_17_155 VPWR VGND sg13g2_decap_8
XFILLER_18_678 VPWR VGND sg13g2_decap_4
XFILLER_33_648 VPWR VGND sg13g2_decap_8
XFILLER_45_442 VPWR VGND sg13g2_decap_8
XFILLER_32_158 VPWR VGND sg13g2_decap_8
X_0881_ VPWR _0240_ daisychain\[47\] VGND sg13g2_inv_1
X_0950_ net114 VGND VPWR _0110_ daisychain\[46\] clknet_5_23__leaf_clk sg13g2_dfrbpq_1
XFILLER_9_354 VPWR VGND sg13g2_decap_8
XFILLER_36_420 VPWR VGND sg13g2_decap_8
XFILLER_49_792 VPWR VGND sg13g2_fill_1
XFILLER_48_280 VPWR VGND sg13g2_decap_8
XFILLER_23_136 VPWR VGND sg13g2_decap_8
XFILLER_24_637 VPWR VGND sg13g2_decap_8
XFILLER_32_692 VPWR VGND sg13g2_fill_1
XFILLER_36_497 VPWR VGND sg13g2_decap_8
XFILLER_11_25 VPWR VGND sg13g2_decap_8
XFILLER_3_508 VPWR VGND sg13g2_decap_8
Xclkbuf_5_10__f_clk clknet_5_10__leaf_clk clknet_4_5_0_clk VPWR VGND sg13g2_buf_16
XFILLER_14_103 VPWR VGND sg13g2_decap_8
XFILLER_15_604 VPWR VGND sg13g2_decap_8
XFILLER_27_420 VPWR VGND sg13g2_decap_8
XFILLER_27_497 VPWR VGND sg13g2_decap_8
XFILLER_36_77 VPWR VGND sg13g2_decap_8
XFILLER_39_280 VPWR VGND sg13g2_decap_8
XFILLER_42_434 VPWR VGND sg13g2_decap_8
XFILLER_46_217 VPWR VGND sg13g2_decap_8
XFILLER_10_342 VPWR VGND sg13g2_decap_8
XFILLER_30_629 VPWR VGND sg13g2_decap_8
XFILLER_42_478 VPWR VGND sg13g2_decap_8
XFILLER_6_368 VPWR VGND sg13g2_decap_8
XFILLER_28_8 VPWR VGND sg13g2_fill_1
XFILLER_37_217 VPWR VGND sg13g2_decap_8
XFILLER_14_692 VPWR VGND sg13g2_decap_4
XFILLER_18_475 VPWR VGND sg13g2_decap_8
XFILLER_33_445 VPWR VGND sg13g2_decap_8
X_0864_ VPWR _0029_ state\[39\] VGND sg13g2_inv_1
X_0933_ net106 VGND VPWR _0093_ daisychain\[29\] clknet_5_6__leaf_clk sg13g2_dfrbpq_1
X_0795_ VPWR _0197_ daisychain\[4\] VGND sg13g2_inv_1
XFILLER_9_151 VPWR VGND sg13g2_decap_8
XFILLER_3_81 VPWR VGND sg13g2_decap_8
XFILLER_47_0 VPWR VGND sg13g2_decap_8
XFILLER_24_434 VPWR VGND sg13g2_decap_8
XFILLER_36_294 VPWR VGND sg13g2_decap_8
XFILLER_20_640 VPWR VGND sg13g2_decap_8
XFILLER_22_35 VPWR VGND sg13g2_decap_8
XFILLER_3_305 VPWR VGND sg13g2_decap_8
XFILLER_19_217 VPWR VGND sg13g2_decap_8
XFILLER_28_740 VPWR VGND sg13g2_decap_8
XFILLER_47_21 VPWR VGND sg13g2_decap_8
XFILLER_47_504 VPWR VGND sg13g2_decap_8
XFILLER_47_98 VPWR VGND sg13g2_decap_8
XFILLER_15_401 VPWR VGND sg13g2_decap_8
XFILLER_15_478 VPWR VGND sg13g2_decap_8
XFILLER_27_294 VPWR VGND sg13g2_decap_8
XFILLER_30_426 VPWR VGND sg13g2_decap_8
XFILLER_42_231 VPWR VGND sg13g2_decap_8
XFILLER_43_721 VPWR VGND sg13g2_decap_8
XFILLER_11_640 VPWR VGND sg13g2_decap_4
XFILLER_12_90 VPWR VGND sg13g2_decap_8
Xdac1 digitalen1.g\[1\].u.OUTP digitalen1.g\[1\].u.OUTN digitalen1.g\[2\].u.OUTP digitalen1.g\[2\].u.OUTN
+ state\[48\] _0007_ state\[49\] _0008_ state\[50\] _0009_ state\[51\] _0010_ state\[52\]
+ _0012_ state\[53\] _0013_ state\[54\] _0014_ state\[55\] _0015_ state\[56\] _0016_
+ state\[57\] _0017_ state\[58\] _0018_ state\[59\] _0019_ state\[60\] _0020_ state\[61\]
+ _0021_ state\[62\] _0023_ state\[63\] _0024_ digitalen1.g\[3\].u.OUTP digitalen1.g\[3\].u.OUTN
+ state\[32\] _0000_ state\[33\] _0011_ state\[34\] _0022_ state\[35\] _0025_ state\[36\]
+ _0026_ state\[37\] _0027_ state\[38\] digitalen1.g\[0\].u.OUTP digitalen1.g\[0\].u.OUTN
+ _0028_ state\[39\] _0029_ state\[40\] _0030_ state\[41\] _0031_ state\[42\] _0001_
+ state\[43\] _0002_ state\[44\] _0003_ state\[45\] _0004_ state\[46\] _0005_ state\[47\]
+ _0006_ dac1/Iout dac1/VbiasP[0] dac1/VbiasP[1] dac1/VcascP[1] dac1/VcascP[0] VPWR
+ VGND dac32module
XFILLER_8_48 VPWR VGND sg13g2_decap_8
XFILLER_7_644 VPWR VGND sg13g2_fill_2
XFILLER_7_633 VPWR VGND sg13g2_decap_4
XFILLER_6_165 VPWR VGND sg13g2_decap_8
XFILLER_2_382 VPWR VGND sg13g2_decap_8
XFILLER_38_504 VPWR VGND sg13g2_decap_8
XFILLER_40_7 VPWR VGND sg13g2_decap_8
X_0580_ _0222_ net62 _0345_ _0346_ VPWR VGND sg13g2_a21o_1
XFILLER_18_272 VPWR VGND sg13g2_decap_8
XFILLER_19_4 VPWR VGND sg13g2_decap_4
XFILLER_19_773 VPWR VGND sg13g2_decap_8
XFILLER_25_209 VPWR VGND sg13g2_decap_8
XFILLER_46_581 VPWR VGND sg13g2_decap_8
XFILLER_21_437 VPWR VGND sg13g2_decap_8
XFILLER_33_242 VPWR VGND sg13g2_decap_8
XFILLER_34_787 VPWR VGND sg13g2_fill_2
XFILLER_34_798 VPWR VGND sg13g2_fill_1
X_0916_ net104 VGND VPWR _0076_ daisychain\[12\] clknet_5_4__leaf_clk sg13g2_dfrbpq_1
XFILLER_0_308 VPWR VGND sg13g2_decap_8
X_0847_ VPWR _0223_ daisychain\[30\] VGND sg13g2_inv_1
X_0778_ _0433_ VPWR _0186_ VGND net79 _0018_ sg13g2_o21ai_1
XFILLER_29_548 VPWR VGND sg13g2_decap_8
XFILLER_17_57 VPWR VGND sg13g2_decap_8
XFILLER_24_231 VPWR VGND sg13g2_decap_8
XFILLER_25_732 VPWR VGND sg13g2_decap_8
XFILLER_25_743 VPWR VGND sg13g2_fill_1
XFILLER_37_581 VPWR VGND sg13g2_decap_8
XFILLER_12_459 VPWR VGND sg13g2_decap_8
XFILLER_33_67 VPWR VGND sg13g2_decap_8
XFILLER_3_102 VPWR VGND sg13g2_decap_8
XFILLER_8_419 VPWR VGND sg13g2_decap_8
XFILLER_3_179 VPWR VGND sg13g2_decap_8
Xclkbuf_5_8__f_clk clknet_5_8__leaf_clk clknet_4_4_0_clk VPWR VGND sg13g2_buf_16
XFILLER_35_518 VPWR VGND sg13g2_decap_8
XFILLER_47_301 VPWR VGND sg13g2_decap_8
XFILLER_47_378 VPWR VGND sg13g2_decap_8
XFILLER_15_275 VPWR VGND sg13g2_decap_8
XFILLER_30_223 VPWR VGND sg13g2_decap_8
XFILLER_43_540 VPWR VGND sg13g2_decap_8
X_0701_ VGND VPWR net34 daisychain\[58\] _0437_ net36 sg13g2_a21oi_1
X_0632_ _0235_ net72 _0384_ _0385_ VPWR VGND sg13g2_a21o_1
X_0563_ net85 VPWR _0333_ VGND net64 state\[25\] sg13g2_o21ai_1
XFILLER_7_441 VPWR VGND sg13g2_decap_8
XFILLER_38_301 VPWR VGND sg13g2_decap_8
X_0494_ _0071_ _0280_ _0281_ net39 _0200_ VPWR VGND sg13g2_a22oi_1
XFILLER_19_581 VPWR VGND sg13g2_decap_8
XFILLER_22_735 VPWR VGND sg13g2_decap_8
XFILLER_38_378 VPWR VGND sg13g2_decap_8
X_1046_ state\[62\] net14 VPWR VGND sg13g2_buf_1
XFILLER_21_234 VPWR VGND sg13g2_decap_8
XFILLER_0_105 VPWR VGND sg13g2_decap_8
XFILLER_28_34 VPWR VGND sg13g2_decap_8
XFILLER_29_356 VPWR VGND sg13g2_decap_8
XFILLER_44_348 VPWR VGND sg13g2_decap_8
XFILLER_12_223 VPWR VGND sg13g2_decap_8
XFILLER_40_554 VPWR VGND sg13g2_decap_8
XFILLER_8_216 VPWR VGND sg13g2_decap_8
XFILLER_40_598 VPWR VGND sg13g2_fill_1
Xclkbuf_4_0_0_clk clknet_0_clk clknet_4_0_0_clk VPWR VGND sg13g2_buf_8
XFILLER_4_433 VPWR VGND sg13g2_decap_8
XFILLER_0_650 VPWR VGND sg13g2_fill_2
XFILLER_10_8 VPWR VGND sg13g2_fill_1
XFILLER_48_643 VPWR VGND sg13g2_fill_1
XFILLER_48_632 VPWR VGND sg13g2_decap_8
XFILLER_35_315 VPWR VGND sg13g2_decap_8
XFILLER_47_175 VPWR VGND sg13g2_decap_8
XFILLER_31_554 VPWR VGND sg13g2_decap_8
XFILLER_43_381 VPWR VGND sg13g2_decap_8
X_0615_ net96 VPWR _0372_ VGND net74 state\[38\] sg13g2_o21ai_1
X_0546_ _0084_ _0319_ _0320_ net44 _0213_ VPWR VGND sg13g2_a22oi_1
XFILLER_38_175 VPWR VGND sg13g2_decap_8
X_0477_ VGND VPWR net33 daisychain\[2\] _0269_ net37 sg13g2_a21oi_1
XFILLER_14_47 VPWR VGND sg13g2_decap_8
XFILLER_22_532 VPWR VGND sg13g2_decap_8
XFILLER_26_348 VPWR VGND sg13g2_decap_8
XFILLER_41_307 VPWR VGND sg13g2_decap_8
X_1029_ net100 VGND VPWR _0189_ state\[61\] clknet_5_10__leaf_clk sg13g2_dfrbpq_1
XFILLER_1_469 VPWR VGND sg13g2_decap_8
XFILLER_39_77 VPWR VGND sg13g2_decap_8
XFILLER_17_337 VPWR VGND sg13g2_decap_8
XFILLER_18_805 VPWR VGND sg13g2_fill_1
XFILLER_18_816 VPWR VGND sg13g2_decap_8
XFILLER_25_370 VPWR VGND sg13g2_decap_8
XFILLER_29_153 VPWR VGND sg13g2_decap_8
XFILLER_44_145 VPWR VGND sg13g2_decap_8
XFILLER_13_521 VPWR VGND sg13g2_decap_8
XFILLER_13_598 VPWR VGND sg13g2_decap_8
XFILLER_40_384 VPWR VGND sg13g2_decap_8
XFILLER_4_230 VPWR VGND sg13g2_decap_8
XFILLER_35_112 VPWR VGND sg13g2_decap_8
XFILLER_36_602 VPWR VGND sg13g2_decap_8
XFILLER_36_646 VPWR VGND sg13g2_fill_1
XFILLER_48_462 VPWR VGND sg13g2_decap_8
XFILLER_23_318 VPWR VGND sg13g2_decap_8
XFILLER_31_351 VPWR VGND sg13g2_decap_8
XFILLER_35_189 VPWR VGND sg13g2_decap_8
XFILLER_8_580 VPWR VGND sg13g2_decap_4
X_0529_ VGND VPWR net26 daisychain\[15\] _0308_ net43 sg13g2_a21oi_1
XFILLER_6_81 VPWR VGND sg13g2_decap_8
XFILLER_26_145 VPWR VGND sg13g2_decap_8
XFILLER_27_602 VPWR VGND sg13g2_decap_8
XFILLER_27_679 VPWR VGND sg13g2_decap_8
XFILLER_39_462 VPWR VGND sg13g2_decap_8
XFILLER_10_524 VPWR VGND sg13g2_decap_4
XFILLER_41_115 VPWR VGND sg13g2_decap_8
XFILLER_41_45 VPWR VGND sg13g2_decap_8
XFILLER_1_266 VPWR VGND sg13g2_decap_8
XFILLER_2_39 VPWR VGND sg13g2_decap_8
XFILLER_45_421 VPWR VGND sg13g2_decap_8
XFILLER_17_134 VPWR VGND sg13g2_decap_8
XFILLER_18_657 VPWR VGND sg13g2_decap_8
XFILLER_32_137 VPWR VGND sg13g2_decap_8
XFILLER_33_627 VPWR VGND sg13g2_decap_8
XFILLER_45_498 VPWR VGND sg13g2_decap_8
XFILLER_13_384 VPWR VGND sg13g2_decap_8
XFILLER_40_181 VPWR VGND sg13g2_decap_8
X_0880_ VPWR _0006_ state\[47\] VGND sg13g2_inv_1
XFILLER_9_333 VPWR VGND sg13g2_decap_8
XFILLER_49_4 VPWR VGND sg13g2_decap_8
XFILLER_24_616 VPWR VGND sg13g2_decap_8
XFILLER_36_476 VPWR VGND sg13g2_decap_8
XFILLER_20_800 VPWR VGND sg13g2_fill_2
XFILLER_20_822 VPWR VGND sg13g2_fill_1
XFILLER_23_115 VPWR VGND sg13g2_decap_8
XFILLER_14_159 VPWR VGND sg13g2_decap_8
XFILLER_27_476 VPWR VGND sg13g2_decap_8
XFILLER_30_608 VPWR VGND sg13g2_decap_8
XFILLER_36_56 VPWR VGND sg13g2_decap_8
XFILLER_42_413 VPWR VGND sg13g2_decap_8
XFILLER_10_321 VPWR VGND sg13g2_decap_8
XFILLER_10_398 VPWR VGND sg13g2_decap_8
XFILLER_23_682 VPWR VGND sg13g2_decap_8
XFILLER_6_347 VPWR VGND sg13g2_decap_8
XFILLER_2_564 VPWR VGND sg13g2_decap_4
XFILLER_7_0 VPWR VGND sg13g2_decap_8
XFILLER_18_454 VPWR VGND sg13g2_decap_8
XFILLER_13_181 VPWR VGND sg13g2_decap_8
XFILLER_20_129 VPWR VGND sg13g2_decap_8
XFILLER_21_619 VPWR VGND sg13g2_decap_8
XFILLER_33_424 VPWR VGND sg13g2_decap_8
XFILLER_45_295 VPWR VGND sg13g2_decap_8
X_0932_ net106 VGND VPWR _0092_ daisychain\[28\] clknet_5_14__leaf_clk sg13g2_dfrbpq_1
XFILLER_9_130 VPWR VGND sg13g2_decap_8
X_0863_ VPWR _0231_ daisychain\[38\] VGND sg13g2_inv_1
X_0794_ VPWR _0058_ state\[4\] VGND sg13g2_inv_1
XFILLER_29_719 VPWR VGND sg13g2_decap_8
XFILLER_3_60 VPWR VGND sg13g2_decap_8
XFILLER_24_413 VPWR VGND sg13g2_decap_8
XFILLER_36_273 VPWR VGND sg13g2_decap_8
XFILLER_20_696 VPWR VGND sg13g2_fill_2
XFILLER_0_7 VPWR VGND sg13g2_decap_8
XFILLER_43_700 VPWR VGND sg13g2_decap_8
XFILLER_47_77 VPWR VGND sg13g2_decap_8
XFILLER_15_457 VPWR VGND sg13g2_decap_8
XFILLER_27_273 VPWR VGND sg13g2_decap_8
XFILLER_30_405 VPWR VGND sg13g2_decap_8
XFILLER_42_210 VPWR VGND sg13g2_decap_8
XFILLER_42_287 VPWR VGND sg13g2_decap_8
XFILLER_8_27 VPWR VGND sg13g2_decap_8
XFILLER_10_195 VPWR VGND sg13g2_decap_8
XFILLER_6_144 VPWR VGND sg13g2_decap_8
XFILLER_2_361 VPWR VGND sg13g2_decap_8
XFILLER_18_251 VPWR VGND sg13g2_decap_8
XFILLER_33_221 VPWR VGND sg13g2_decap_8
XFILLER_46_560 VPWR VGND sg13g2_decap_8
XFILLER_21_416 VPWR VGND sg13g2_decap_8
XFILLER_33_298 VPWR VGND sg13g2_decap_8
X_0915_ net104 VGND VPWR _0075_ daisychain\[11\] clknet_5_4__leaf_clk sg13g2_dfrbpq_1
X_0846_ VPWR _0055_ state\[30\] VGND sg13g2_inv_1
X_0777_ _0430_ VPWR _0185_ VGND net99 _0017_ sg13g2_o21ai_1
XFILLER_29_527 VPWR VGND sg13g2_decap_8
XFILLER_37_560 VPWR VGND sg13g2_decap_8
XFILLER_44_508 VPWR VGND sg13g2_decap_8
XFILLER_12_438 VPWR VGND sg13g2_decap_8
XFILLER_24_210 VPWR VGND sg13g2_decap_8
XFILLER_24_287 VPWR VGND sg13g2_decap_8
XFILLER_25_711 VPWR VGND sg13g2_decap_8
XFILLER_25_777 VPWR VGND sg13g2_decap_8
XFILLER_25_799 VPWR VGND sg13g2_decap_8
XFILLER_33_46 VPWR VGND sg13g2_decap_8
XFILLER_20_493 VPWR VGND sg13g2_decap_8
XFILLER_3_158 VPWR VGND sg13g2_decap_8
XFILLER_47_357 VPWR VGND sg13g2_decap_8
XFILLER_15_254 VPWR VGND sg13g2_decap_8
XFILLER_30_202 VPWR VGND sg13g2_decap_8
XFILLER_30_279 VPWR VGND sg13g2_decap_8
X_0700_ _0252_ net58 _0435_ _0436_ VPWR VGND sg13g2_a21o_1
XFILLER_7_420 VPWR VGND sg13g2_decap_8
X_0631_ net94 VPWR _0384_ VGND net72 state\[42\] sg13g2_o21ai_1
X_0562_ _0088_ _0331_ _0332_ net42 _0217_ VPWR VGND sg13g2_a22oi_1
XFILLER_7_497 VPWR VGND sg13g2_decap_8
XFILLER_19_560 VPWR VGND sg13g2_decap_8
XFILLER_38_357 VPWR VGND sg13g2_decap_8
X_0493_ VGND VPWR net24 daisychain\[6\] _0281_ net39 sg13g2_a21oi_1
XFILLER_21_213 VPWR VGND sg13g2_decap_8
XFILLER_34_585 VPWR VGND sg13g2_decap_8
X_1045_ state\[61\] net13 VPWR VGND sg13g2_buf_1
X_0829_ VPWR _0214_ daisychain\[21\] VGND sg13g2_inv_1
XFILLER_9_81 VPWR VGND sg13g2_decap_8
XFILLER_28_13 VPWR VGND sg13g2_decap_8
XFILLER_17_519 VPWR VGND sg13g2_decap_8
XFILLER_29_335 VPWR VGND sg13g2_decap_8
XFILLER_44_327 VPWR VGND sg13g2_decap_8
XFILLER_12_202 VPWR VGND sg13g2_decap_8
XFILLER_12_279 VPWR VGND sg13g2_decap_8
XFILLER_13_769 VPWR VGND sg13g2_decap_8
XFILLER_25_585 VPWR VGND sg13g2_decap_8
XFILLER_40_533 VPWR VGND sg13g2_decap_8
XFILLER_44_89 VPWR VGND sg13g2_decap_8
XFILLER_20_290 VPWR VGND sg13g2_decap_8
XFILLER_5_39 VPWR VGND sg13g2_decap_8
XFILLER_4_489 VPWR VGND sg13g2_decap_8
XFILLER_4_412 VPWR VGND sg13g2_decap_8
XFILLER_0_684 VPWR VGND sg13g2_fill_2
XFILLER_47_154 VPWR VGND sg13g2_decap_8
XFILLER_16_585 VPWR VGND sg13g2_decap_8
XFILLER_18_90 VPWR VGND sg13g2_decap_8
XFILLER_31_533 VPWR VGND sg13g2_decap_8
XFILLER_43_360 VPWR VGND sg13g2_decap_8
X_0614_ _0101_ _0370_ _0371_ net47 _0230_ VPWR VGND sg13g2_a22oi_1
X_0545_ VGND VPWR net32 daisychain\[19\] _0320_ net44 sg13g2_a21oi_1
X_0476_ _0196_ net77 _0267_ _0268_ VPWR VGND sg13g2_a21o_1
XFILLER_7_294 VPWR VGND sg13g2_decap_8
XFILLER_26_327 VPWR VGND sg13g2_decap_8
XFILLER_38_154 VPWR VGND sg13g2_decap_8
XFILLER_39_688 VPWR VGND sg13g2_fill_1
XFILLER_39_699 VPWR VGND sg13g2_decap_8
XFILLER_14_26 VPWR VGND sg13g2_decap_8
XFILLER_22_511 VPWR VGND sg13g2_decap_8
XFILLER_22_588 VPWR VGND sg13g2_decap_8
XFILLER_34_382 VPWR VGND sg13g2_decap_8
X_1028_ net101 VGND VPWR _0188_ state\[60\] clknet_5_18__leaf_clk sg13g2_dfrbpq_1
XFILLER_30_69 VPWR VGND sg13g2_decap_8
Xdigitalen1.g\[0\].u.inv1 VPWR digitalen1.g\[0\].u.OUTN net7 VGND sg13g2_inv_1
XFILLER_1_448 VPWR VGND sg13g2_decap_8
XFILLER_29_132 VPWR VGND sg13g2_decap_8
XFILLER_39_56 VPWR VGND sg13g2_decap_8
XFILLER_45_603 VPWR VGND sg13g2_fill_2
XFILLER_13_500 VPWR VGND sg13g2_decap_8
XFILLER_17_316 VPWR VGND sg13g2_decap_8
XFILLER_32_319 VPWR VGND sg13g2_decap_8
XFILLER_33_809 VPWR VGND sg13g2_decap_8
XFILLER_44_124 VPWR VGND sg13g2_decap_8
XFILLER_45_658 VPWR VGND sg13g2_fill_2
XFILLER_13_577 VPWR VGND sg13g2_decap_8
XFILLER_40_363 VPWR VGND sg13g2_decap_8
XFILLER_9_515 VPWR VGND sg13g2_decap_4
XFILLER_20_80 VPWR VGND sg13g2_decap_8
XFILLER_4_286 VPWR VGND sg13g2_decap_8
XFILLER_36_658 VPWR VGND sg13g2_fill_1
XFILLER_48_441 VPWR VGND sg13g2_decap_8
XFILLER_16_382 VPWR VGND sg13g2_decap_8
XFILLER_31_330 VPWR VGND sg13g2_decap_8
XFILLER_35_168 VPWR VGND sg13g2_decap_8
XFILLER_8_592 VPWR VGND sg13g2_fill_1
XFILLER_6_60 VPWR VGND sg13g2_decap_8
XFILLER_39_441 VPWR VGND sg13g2_decap_8
X_0528_ _0209_ net65 _0306_ _0307_ VPWR VGND sg13g2_a21o_1
X_0459_ VPWR _0255_ daisychain\[62\] VGND sg13g2_inv_1
XFILLER_25_69 VPWR VGND sg13g2_decap_8
XFILLER_26_124 VPWR VGND sg13g2_decap_8
XFILLER_27_658 VPWR VGND sg13g2_decap_8
XFILLER_35_680 VPWR VGND sg13g2_decap_8
XFILLER_42_617 VPWR VGND sg13g2_fill_1
XFILLER_10_503 VPWR VGND sg13g2_decap_8
XFILLER_22_385 VPWR VGND sg13g2_decap_8
XFILLER_6_529 VPWR VGND sg13g2_decap_8
XFILLER_1_245 VPWR VGND sg13g2_decap_8
XFILLER_9_4 VPWR VGND sg13g2_decap_8
XFILLER_17_113 VPWR VGND sg13g2_decap_8
XFILLER_18_636 VPWR VGND sg13g2_decap_8
XFILLER_2_18 VPWR VGND sg13g2_decap_8
XFILLER_45_400 VPWR VGND sg13g2_decap_8
XFILLER_49_249 VPWR VGND sg13g2_decap_8
XFILLER_13_363 VPWR VGND sg13g2_decap_8
XFILLER_26_691 VPWR VGND sg13g2_decap_8
XFILLER_32_116 VPWR VGND sg13g2_decap_8
XFILLER_33_606 VPWR VGND sg13g2_decap_8
XFILLER_45_477 VPWR VGND sg13g2_decap_8
XFILLER_9_312 VPWR VGND sg13g2_decap_8
XFILLER_9_389 VPWR VGND sg13g2_decap_8
XFILLER_5_584 VPWR VGND sg13g2_decap_8
XFILLER_36_455 VPWR VGND sg13g2_decap_8
XFILLER_49_772 VPWR VGND sg13g2_fill_2
XFILLER_32_683 VPWR VGND sg13g2_decap_8
XFILLER_36_35 VPWR VGND sg13g2_decap_8
XFILLER_10_300 VPWR VGND sg13g2_decap_8
XFILLER_14_138 VPWR VGND sg13g2_decap_8
XFILLER_15_628 VPWR VGND sg13g2_fill_1
XFILLER_23_661 VPWR VGND sg13g2_decap_8
XFILLER_27_455 VPWR VGND sg13g2_decap_8
XFILLER_10_377 VPWR VGND sg13g2_decap_8
XFILLER_22_182 VPWR VGND sg13g2_decap_8
XFILLER_6_326 VPWR VGND sg13g2_decap_8
XFILLER_2_543 VPWR VGND sg13g2_decap_8
XFILLER_2_598 VPWR VGND sg13g2_fill_2
XFILLER_18_433 VPWR VGND sg13g2_decap_8
XFILLER_33_403 VPWR VGND sg13g2_decap_8
XFILLER_45_274 VPWR VGND sg13g2_decap_8
XFILLER_13_160 VPWR VGND sg13g2_decap_8
XFILLER_20_108 VPWR VGND sg13g2_decap_8
X_0862_ VPWR _0028_ state\[38\] VGND sg13g2_inv_1
X_0931_ net106 VGND VPWR _0091_ daisychain\[27\] clknet_5_17__leaf_clk sg13g2_dfrbpq_1
X_0793_ VPWR _0196_ daisychain\[3\] VGND sg13g2_inv_1
XFILLER_9_186 VPWR VGND sg13g2_decap_8
XFILLER_37_731 VPWR VGND sg13g2_fill_2
XFILLER_24_469 VPWR VGND sg13g2_decap_8
XFILLER_36_252 VPWR VGND sg13g2_decap_8
XFILLER_20_675 VPWR VGND sg13g2_decap_8
XFILLER_32_480 VPWR VGND sg13g2_decap_8
Xfanout110 net118 net110 VPWR VGND sg13g2_buf_1
XFILLER_15_436 VPWR VGND sg13g2_decap_8
XFILLER_27_252 VPWR VGND sg13g2_decap_8
XFILLER_28_753 VPWR VGND sg13g2_decap_4
XFILLER_28_775 VPWR VGND sg13g2_decap_8
XFILLER_28_786 VPWR VGND sg13g2_fill_1
XFILLER_47_539 VPWR VGND sg13g2_decap_8
XFILLER_47_56 VPWR VGND sg13g2_decap_8
XFILLER_11_631 VPWR VGND sg13g2_fill_1
XFILLER_42_266 VPWR VGND sg13g2_decap_8
XFILLER_10_174 VPWR VGND sg13g2_decap_8
XFILLER_2_340 VPWR VGND sg13g2_decap_8
XFILLER_6_123 VPWR VGND sg13g2_decap_8
XFILLER_38_539 VPWR VGND sg13g2_decap_8
XFILLER_18_230 VPWR VGND sg13g2_decap_8
XFILLER_33_200 VPWR VGND sg13g2_decap_8
XFILLER_33_277 VPWR VGND sg13g2_decap_8
X_0914_ net104 VGND VPWR _0074_ daisychain\[10\] clknet_5_4__leaf_clk sg13g2_dfrbpq_1
X_0845_ VPWR _0222_ daisychain\[29\] VGND sg13g2_inv_1
X_0776_ _0427_ VPWR _0184_ VGND net92 _0016_ sg13g2_o21ai_1
XFILLER_12_417 VPWR VGND sg13g2_decap_8
XFILLER_24_266 VPWR VGND sg13g2_decap_8
XFILLER_33_25 VPWR VGND sg13g2_decap_8
XFILLER_40_737 VPWR VGND sg13g2_fill_1
XFILLER_20_472 VPWR VGND sg13g2_decap_8
XFILLER_3_137 VPWR VGND sg13g2_decap_8
XFILLER_0_811 VPWR VGND sg13g2_decap_8
XFILLER_0_822 VPWR VGND sg13g2_fill_1
XFILLER_47_336 VPWR VGND sg13g2_decap_8
XFILLER_15_233 VPWR VGND sg13g2_decap_8
XFILLER_28_594 VPWR VGND sg13g2_decap_8
XFILLER_43_575 VPWR VGND sg13g2_decap_8
XFILLER_23_80 VPWR VGND sg13g2_decap_8
XFILLER_30_258 VPWR VGND sg13g2_decap_8
XFILLER_7_476 VPWR VGND sg13g2_decap_8
X_0630_ _0105_ _0382_ _0383_ net51 _0234_ VPWR VGND sg13g2_a22oi_1
X_0561_ VGND VPWR net26 daisychain\[23\] _0332_ net42 sg13g2_a21oi_1
X_0492_ _0200_ net59 _0279_ _0280_ VPWR VGND sg13g2_a21o_1
XFILLER_26_509 VPWR VGND sg13g2_decap_8
XFILLER_38_336 VPWR VGND sg13g2_decap_8
X_1044_ state\[60\] net12 VPWR VGND sg13g2_buf_1
XFILLER_0_84 VPWR VGND sg13g2_decap_8
XFILLER_21_269 VPWR VGND sg13g2_decap_8
XFILLER_34_564 VPWR VGND sg13g2_decap_8
XFILLER_9_60 VPWR VGND sg13g2_decap_8
X_0828_ VPWR _0045_ state\[21\] VGND sg13g2_inv_1
X_0759_ _0376_ VPWR _0167_ VGND net96 _0029_ sg13g2_o21ai_1
XFILLER_29_314 VPWR VGND sg13g2_decap_8
XFILLER_25_564 VPWR VGND sg13g2_decap_8
XFILLER_28_69 VPWR VGND sg13g2_decap_8
XFILLER_44_306 VPWR VGND sg13g2_decap_8
XFILLER_44_68 VPWR VGND sg13g2_decap_8
XFILLER_12_258 VPWR VGND sg13g2_decap_8
XFILLER_40_512 VPWR VGND sg13g2_decap_8
XFILLER_40_589 VPWR VGND sg13g2_decap_8
Xclkbuf_5_16__f_clk clknet_5_16__leaf_clk clknet_4_8_0_clk VPWR VGND sg13g2_buf_16
XFILLER_5_18 VPWR VGND sg13g2_decap_8
XFILLER_4_468 VPWR VGND sg13g2_decap_8
XFILLER_0_652 VPWR VGND sg13g2_fill_1
XFILLER_0_663 VPWR VGND sg13g2_decap_8
XFILLER_36_818 VPWR VGND sg13g2_decap_4
XFILLER_47_133 VPWR VGND sg13g2_decap_8
XFILLER_48_623 VPWR VGND sg13g2_decap_4
XFILLER_16_564 VPWR VGND sg13g2_decap_8
XFILLER_28_391 VPWR VGND sg13g2_decap_8
XFILLER_31_512 VPWR VGND sg13g2_decap_8
XFILLER_11_291 VPWR VGND sg13g2_decap_8
XFILLER_31_589 VPWR VGND sg13g2_decap_8
X_0613_ VGND VPWR net28 daisychain\[36\] _0371_ net47 sg13g2_a21oi_1
XFILLER_7_273 VPWR VGND sg13g2_decap_8
X_0544_ _0213_ net66 _0318_ _0319_ VPWR VGND sg13g2_a21o_1
X_0475_ net99 VPWR _0267_ VGND net77 state\[3\] sg13g2_o21ai_1
XFILLER_15_0 VPWR VGND sg13g2_fill_2
XFILLER_26_306 VPWR VGND sg13g2_decap_8
XFILLER_34_361 VPWR VGND sg13g2_decap_8
XFILLER_38_133 VPWR VGND sg13g2_decap_8
XFILLER_39_667 VPWR VGND sg13g2_decap_8
X_1027_ net101 VGND VPWR _0187_ state\[59\] clknet_5_18__leaf_clk sg13g2_dfrbpq_1
XFILLER_22_567 VPWR VGND sg13g2_decap_8
XFILLER_1_427 VPWR VGND sg13g2_decap_8
XFILLER_30_48 VPWR VGND sg13g2_decap_8
XFILLER_39_13 VPWR VGND sg13g2_decap_8
Xdigitalen1.g\[0\].u.inv2 VPWR digitalen1.g\[0\].u.OUTP digitalen1.g\[0\].u.OUTN VGND
+ sg13g2_inv_1
XFILLER_29_111 VPWR VGND sg13g2_decap_8
XFILLER_29_188 VPWR VGND sg13g2_decap_8
XFILLER_39_35 VPWR VGND sg13g2_decap_8
XFILLER_44_103 VPWR VGND sg13g2_decap_8
XFILLER_45_637 VPWR VGND sg13g2_decap_4
XFILLER_13_556 VPWR VGND sg13g2_decap_8
XFILLER_40_342 VPWR VGND sg13g2_decap_8
XFILLER_4_265 VPWR VGND sg13g2_decap_8
XFILLER_48_420 VPWR VGND sg13g2_decap_8
XFILLER_29_90 VPWR VGND sg13g2_decap_8
XFILLER_35_147 VPWR VGND sg13g2_decap_8
XFILLER_36_637 VPWR VGND sg13g2_decap_8
XFILLER_48_497 VPWR VGND sg13g2_decap_8
XFILLER_16_361 VPWR VGND sg13g2_decap_8
XFILLER_31_386 VPWR VGND sg13g2_decap_8
XFILLER_32_821 VPWR VGND sg13g2_fill_2
XFILLER_26_103 VPWR VGND sg13g2_decap_8
XFILLER_39_420 VPWR VGND sg13g2_decap_8
X_0527_ net86 VPWR _0306_ VGND net65 state\[16\] sg13g2_o21ai_1
X_0458_ VPWR _0023_ state\[62\] VGND sg13g2_inv_1
XFILLER_23_821 VPWR VGND sg13g2_fill_2
XFILLER_25_48 VPWR VGND sg13g2_decap_8
XFILLER_27_637 VPWR VGND sg13g2_decap_8
XFILLER_39_497 VPWR VGND sg13g2_decap_8
XFILLER_22_364 VPWR VGND sg13g2_decap_8
XFILLER_41_14 VPWR VGND sg13g2_fill_1
XFILLER_6_508 VPWR VGND sg13g2_decap_8
XFILLER_1_224 VPWR VGND sg13g2_decap_8
XFILLER_49_228 VPWR VGND sg13g2_decap_8
XFILLER_17_169 VPWR VGND sg13g2_decap_8
XFILLER_18_615 VPWR VGND sg13g2_decap_8
XFILLER_45_456 VPWR VGND sg13g2_decap_8
XFILLER_13_342 VPWR VGND sg13g2_decap_8
XFILLER_26_670 VPWR VGND sg13g2_decap_8
XFILLER_9_368 VPWR VGND sg13g2_decap_8
XFILLER_49_784 VPWR VGND sg13g2_fill_1
XFILLER_36_434 VPWR VGND sg13g2_decap_8
XFILLER_48_294 VPWR VGND sg13g2_decap_8
XFILLER_11_39 VPWR VGND sg13g2_decap_8
XFILLER_20_802 VPWR VGND sg13g2_fill_1
XFILLER_20_813 VPWR VGND sg13g2_decap_8
XFILLER_31_183 VPWR VGND sg13g2_decap_8
XFILLER_32_662 VPWR VGND sg13g2_decap_8
XFILLER_15_618 VPWR VGND sg13g2_decap_4
XFILLER_27_434 VPWR VGND sg13g2_decap_8
XFILLER_36_14 VPWR VGND sg13g2_decap_8
XFILLER_39_294 VPWR VGND sg13g2_decap_8
XFILLER_14_117 VPWR VGND sg13g2_decap_8
XFILLER_22_161 VPWR VGND sg13g2_decap_8
XFILLER_23_640 VPWR VGND sg13g2_decap_8
XFILLER_42_448 VPWR VGND sg13g2_decap_4
XFILLER_10_356 VPWR VGND sg13g2_decap_8
XFILLER_2_522 VPWR VGND sg13g2_decap_8
XFILLER_6_305 VPWR VGND sg13g2_decap_8
XFILLER_18_412 VPWR VGND sg13g2_decap_8
XFILLER_18_489 VPWR VGND sg13g2_decap_8
XFILLER_33_459 VPWR VGND sg13g2_decap_8
XFILLER_45_253 VPWR VGND sg13g2_decap_8
X_0861_ VPWR _0230_ daisychain\[37\] VGND sg13g2_inv_1
X_0930_ net103 VGND VPWR _0090_ daisychain\[26\] clknet_5_8__leaf_clk sg13g2_dfrbpq_1
X_0792_ VPWR _0057_ state\[3\] VGND sg13g2_inv_1
XFILLER_9_165 VPWR VGND sg13g2_decap_8
XFILLER_5_382 VPWR VGND sg13g2_decap_8
XFILLER_28_209 VPWR VGND sg13g2_decap_8
XFILLER_36_231 VPWR VGND sg13g2_decap_8
XFILLER_37_743 VPWR VGND sg13g2_fill_1
XFILLER_37_776 VPWR VGND sg13g2_fill_2
XFILLER_3_95 VPWR VGND sg13g2_decap_8
XFILLER_49_592 VPWR VGND sg13g2_decap_8
XFILLER_11_109 VPWR VGND sg13g2_decap_8
XFILLER_24_448 VPWR VGND sg13g2_decap_8
XFILLER_20_654 VPWR VGND sg13g2_decap_8
XFILLER_22_49 VPWR VGND sg13g2_decap_8
XFILLER_3_319 VPWR VGND sg13g2_decap_8
XFILLER_47_35 VPWR VGND sg13g2_decap_8
XFILLER_47_518 VPWR VGND sg13g2_decap_8
Xfanout100 net1 net100 VPWR VGND sg13g2_buf_1
Xfanout111 net113 net111 VPWR VGND sg13g2_buf_1
XFILLER_15_415 VPWR VGND sg13g2_decap_8
XFILLER_27_231 VPWR VGND sg13g2_decap_8
XFILLER_42_245 VPWR VGND sg13g2_decap_8
XFILLER_43_735 VPWR VGND sg13g2_decap_4
XFILLER_10_153 VPWR VGND sg13g2_decap_8
XFILLER_7_614 VPWR VGND sg13g2_fill_2
XFILLER_6_102 VPWR VGND sg13g2_decap_8
XFILLER_6_179 VPWR VGND sg13g2_decap_8
XFILLER_2_396 VPWR VGND sg13g2_decap_8
XFILLER_34_702 VPWR VGND sg13g2_fill_1
XFILLER_38_518 VPWR VGND sg13g2_decap_8
XFILLER_14_481 VPWR VGND sg13g2_decap_8
XFILLER_18_286 VPWR VGND sg13g2_decap_8
XFILLER_33_256 VPWR VGND sg13g2_decap_8
XFILLER_46_595 VPWR VGND sg13g2_decap_8
X_0913_ net104 VGND VPWR _0073_ daisychain\[9\] clknet_5_15__leaf_clk sg13g2_dfrbpq_1
X_0844_ VPWR _0053_ state\[29\] VGND sg13g2_inv_1
X_0775_ _0424_ VPWR _0183_ VGND net92 _0015_ sg13g2_o21ai_1
XFILLER_45_0 VPWR VGND sg13g2_decap_8
XFILLER_24_245 VPWR VGND sg13g2_decap_8
XFILLER_37_595 VPWR VGND sg13g2_decap_8
XFILLER_20_451 VPWR VGND sg13g2_decap_8
XFILLER_40_705 VPWR VGND sg13g2_fill_2
XFILLER_3_116 VPWR VGND sg13g2_decap_8
XFILLER_4_639 VPWR VGND sg13g2_fill_2
XFILLER_47_315 VPWR VGND sg13g2_decap_8
XFILLER_15_212 VPWR VGND sg13g2_decap_8
XFILLER_15_289 VPWR VGND sg13g2_decap_8
XFILLER_28_573 VPWR VGND sg13g2_decap_8
XFILLER_30_237 VPWR VGND sg13g2_decap_8
XFILLER_43_554 VPWR VGND sg13g2_decap_8
XFILLER_43_598 VPWR VGND sg13g2_fill_2
XFILLER_11_473 VPWR VGND sg13g2_decap_4
XFILLER_7_455 VPWR VGND sg13g2_decap_8
XFILLER_2_193 VPWR VGND sg13g2_decap_8
X_0560_ _0217_ net64 _0330_ _0331_ VPWR VGND sg13g2_a21o_1
X_0491_ net81 VPWR _0279_ VGND net59 state\[7\] sg13g2_o21ai_1
XFILLER_0_63 VPWR VGND sg13g2_decap_8
XFILLER_19_595 VPWR VGND sg13g2_decap_8
XFILLER_34_543 VPWR VGND sg13g2_decap_8
XFILLER_38_315 VPWR VGND sg13g2_decap_8
XFILLER_46_392 VPWR VGND sg13g2_decap_8
X_1043_ state\[59\] net11 VPWR VGND sg13g2_buf_1
XFILLER_21_248 VPWR VGND sg13g2_decap_8
XFILLER_30_793 VPWR VGND sg13g2_fill_2
X_0827_ VPWR _0213_ daisychain\[20\] VGND sg13g2_inv_1
X_0758_ _0373_ VPWR _0166_ VGND net96 _0028_ sg13g2_o21ai_1
XFILLER_0_119 VPWR VGND sg13g2_decap_8
XFILLER_28_48 VPWR VGND sg13g2_decap_8
X_0689_ VGND VPWR net31 daisychain\[55\] _0428_ net48 sg13g2_a21oi_1
XFILLER_25_543 VPWR VGND sg13g2_decap_8
XFILLER_37_392 VPWR VGND sg13g2_decap_8
XFILLER_44_14 VPWR VGND sg13g2_decap_8
XFILLER_12_237 VPWR VGND sg13g2_decap_8
XFILLER_40_568 VPWR VGND sg13g2_decap_8
XFILLER_4_447 VPWR VGND sg13g2_decap_8
XFILLER_48_602 VPWR VGND sg13g2_decap_8
XFILLER_0_686 VPWR VGND sg13g2_fill_1
XFILLER_0_697 VPWR VGND sg13g2_fill_1
XFILLER_16_543 VPWR VGND sg13g2_decap_8
XFILLER_28_370 VPWR VGND sg13g2_decap_8
XFILLER_35_329 VPWR VGND sg13g2_decap_8
XFILLER_47_112 VPWR VGND sg13g2_decap_8
XFILLER_47_189 VPWR VGND sg13g2_decap_8
XFILLER_31_568 VPWR VGND sg13g2_decap_8
XFILLER_43_395 VPWR VGND sg13g2_decap_8
XFILLER_11_270 VPWR VGND sg13g2_decap_8
X_0612_ _0230_ net69 _0369_ _0370_ VPWR VGND sg13g2_a21o_1
XFILLER_7_252 VPWR VGND sg13g2_decap_8
XFILLER_27_819 VPWR VGND sg13g2_decap_4
XFILLER_38_112 VPWR VGND sg13g2_decap_8
XFILLER_39_602 VPWR VGND sg13g2_fill_2
XFILLER_3_480 VPWR VGND sg13g2_decap_8
X_0543_ net86 VPWR _0318_ VGND net66 state\[20\] sg13g2_o21ai_1
X_0474_ _0066_ _0265_ _0266_ net37 _0195_ VPWR VGND sg13g2_a22oi_1
XFILLER_19_392 VPWR VGND sg13g2_decap_8
XFILLER_34_340 VPWR VGND sg13g2_decap_8
XFILLER_38_189 VPWR VGND sg13g2_decap_8
X_1026_ net101 VGND VPWR _0186_ state\[58\] clknet_5_26__leaf_clk sg13g2_dfrbpq_1
Xclkbuf_5_22__f_clk clknet_5_22__leaf_clk clknet_4_11_0_clk VPWR VGND sg13g2_buf_16
XFILLER_22_546 VPWR VGND sg13g2_decap_8
XFILLER_1_406 VPWR VGND sg13g2_decap_8
XFILLER_29_167 VPWR VGND sg13g2_decap_8
XFILLER_13_535 VPWR VGND sg13g2_decap_8
XFILLER_25_384 VPWR VGND sg13g2_decap_8
XFILLER_40_321 VPWR VGND sg13g2_decap_8
XFILLER_44_159 VPWR VGND sg13g2_decap_8
XFILLER_40_398 VPWR VGND sg13g2_decap_8
XFILLER_4_244 VPWR VGND sg13g2_decap_8
XFILLER_0_483 VPWR VGND sg13g2_decap_8
XFILLER_16_340 VPWR VGND sg13g2_decap_8
XFILLER_35_126 VPWR VGND sg13g2_decap_8
XFILLER_36_616 VPWR VGND sg13g2_decap_8
XFILLER_48_476 VPWR VGND sg13g2_decap_8
XFILLER_31_365 VPWR VGND sg13g2_decap_8
XFILLER_43_192 VPWR VGND sg13g2_decap_8
X_0526_ _0079_ _0304_ _0305_ net46 _0208_ VPWR VGND sg13g2_a22oi_1
XFILLER_6_95 VPWR VGND sg13g2_decap_8
XFILLER_27_616 VPWR VGND sg13g2_decap_8
XFILLER_39_476 VPWR VGND sg13g2_decap_8
X_0457_ VPWR _0254_ daisychain\[61\] VGND sg13g2_inv_1
XFILLER_22_343 VPWR VGND sg13g2_decap_8
XFILLER_25_27 VPWR VGND sg13g2_decap_8
XFILLER_26_159 VPWR VGND sg13g2_decap_8
XFILLER_41_129 VPWR VGND sg13g2_decap_8
X_1009_ net115 VGND VPWR _0169_ state\[41\] clknet_5_22__leaf_clk sg13g2_dfrbpq_1
XFILLER_41_59 VPWR VGND sg13g2_decap_8
XFILLER_1_203 VPWR VGND sg13g2_decap_8
XFILLER_2_748 VPWR VGND sg13g2_decap_4
XFILLER_49_207 VPWR VGND sg13g2_decap_8
XFILLER_14_822 VPWR VGND sg13g2_fill_1
XFILLER_17_148 VPWR VGND sg13g2_decap_8
XFILLER_45_435 VPWR VGND sg13g2_decap_8
XFILLER_13_321 VPWR VGND sg13g2_decap_8
XFILLER_15_93 VPWR VGND sg13g2_decap_8
XFILLER_25_181 VPWR VGND sg13g2_decap_8
XFILLER_40_195 VPWR VGND sg13g2_decap_8
XFILLER_41_652 VPWR VGND sg13g2_decap_8
XFILLER_41_663 VPWR VGND sg13g2_fill_1
XFILLER_41_696 VPWR VGND sg13g2_decap_4
XFILLER_9_347 VPWR VGND sg13g2_decap_8
XFILLER_31_92 VPWR VGND sg13g2_decap_8
XFILLER_0_280 VPWR VGND sg13g2_decap_8
XFILLER_36_413 VPWR VGND sg13g2_decap_8
XFILLER_49_774 VPWR VGND sg13g2_fill_1
XFILLER_48_273 VPWR VGND sg13g2_decap_8
XFILLER_23_129 VPWR VGND sg13g2_decap_8
XFILLER_32_641 VPWR VGND sg13g2_decap_8
XFILLER_11_18 VPWR VGND sg13g2_decap_8
XFILLER_31_162 VPWR VGND sg13g2_decap_8
XFILLER_8_391 VPWR VGND sg13g2_decap_8
X_0509_ VGND VPWR net24 daisychain\[10\] _0293_ net38 sg13g2_a21oi_1
XFILLER_27_413 VPWR VGND sg13g2_decap_8
XFILLER_39_273 VPWR VGND sg13g2_decap_8
XFILLER_42_427 VPWR VGND sg13g2_decap_8
XFILLER_10_335 VPWR VGND sg13g2_decap_8
XFILLER_22_140 VPWR VGND sg13g2_decap_8
XFILLER_23_696 VPWR VGND sg13g2_decap_8
XFILLER_35_490 VPWR VGND sg13g2_decap_8
XFILLER_2_501 VPWR VGND sg13g2_decap_8
XFILLER_18_468 VPWR VGND sg13g2_decap_8
XFILLER_33_438 VPWR VGND sg13g2_decap_8
XFILLER_45_232 VPWR VGND sg13g2_decap_8
XFILLER_13_195 VPWR VGND sg13g2_decap_8
XFILLER_14_685 VPWR VGND sg13g2_decap_8
XFILLER_41_482 VPWR VGND sg13g2_decap_8
X_0860_ VPWR _0027_ state\[37\] VGND sg13g2_inv_1
X_0791_ VPWR _0195_ daisychain\[2\] VGND sg13g2_inv_1
XFILLER_9_144 VPWR VGND sg13g2_decap_8
XFILLER_3_74 VPWR VGND sg13g2_decap_8
XFILLER_5_361 VPWR VGND sg13g2_decap_8
XFILLER_24_427 VPWR VGND sg13g2_decap_8
XFILLER_36_210 VPWR VGND sg13g2_decap_8
XFILLER_36_287 VPWR VGND sg13g2_decap_8
XFILLER_49_571 VPWR VGND sg13g2_decap_8
XFILLER_20_633 VPWR VGND sg13g2_decap_8
X_0989_ net110 VGND VPWR _0149_ state\[21\] clknet_5_3__leaf_clk sg13g2_dfrbpq_1
XFILLER_27_210 VPWR VGND sg13g2_decap_8
XFILLER_28_733 VPWR VGND sg13g2_decap_8
XFILLER_47_14 VPWR VGND sg13g2_decap_8
Xfanout101 net1 net101 VPWR VGND sg13g2_buf_1
Xfanout112 net113 net112 VPWR VGND sg13g2_buf_1
XFILLER_27_287 VPWR VGND sg13g2_decap_8
XFILLER_30_419 VPWR VGND sg13g2_decap_8
XFILLER_42_224 VPWR VGND sg13g2_decap_8
XFILLER_43_714 VPWR VGND sg13g2_decap_8
Xdigitalen0.g\[1\].u.inv1 VPWR digitalen0.g\[1\].u.OUTN net6 VGND sg13g2_inv_1
XFILLER_10_132 VPWR VGND sg13g2_decap_8
XFILLER_23_493 VPWR VGND sg13g2_decap_8
XFILLER_7_637 VPWR VGND sg13g2_fill_1
XFILLER_7_626 VPWR VGND sg13g2_decap_8
XFILLER_6_158 VPWR VGND sg13g2_decap_8
XFILLER_12_83 VPWR VGND sg13g2_decap_8
XFILLER_2_375 VPWR VGND sg13g2_decap_8
XFILLER_3_821 VPWR VGND sg13g2_fill_2
XFILLER_18_265 VPWR VGND sg13g2_decap_8
XFILLER_19_8 VPWR VGND sg13g2_fill_1
XFILLER_37_91 VPWR VGND sg13g2_decap_8
XFILLER_46_574 VPWR VGND sg13g2_decap_8
Xclkbuf_5_3__f_clk clknet_5_3__leaf_clk clknet_4_1_0_clk VPWR VGND sg13g2_buf_16
XFILLER_14_460 VPWR VGND sg13g2_decap_8
XFILLER_33_235 VPWR VGND sg13g2_decap_8
XFILLER_34_758 VPWR VGND sg13g2_fill_2
X_0912_ net104 VGND VPWR _0072_ daisychain\[8\] clknet_5_15__leaf_clk sg13g2_dfrbpq_1
X_0843_ VPWR _0221_ daisychain\[28\] VGND sg13g2_inv_1
X_0774_ _0421_ VPWR _0182_ VGND net91 _0014_ sg13g2_o21ai_1
XFILLER_38_0 VPWR VGND sg13g2_decap_8
XFILLER_17_28 VPWR VGND sg13g2_fill_2
XFILLER_24_224 VPWR VGND sg13g2_decap_8
XFILLER_25_725 VPWR VGND sg13g2_decap_8
XFILLER_25_769 VPWR VGND sg13g2_fill_2
XFILLER_37_574 VPWR VGND sg13g2_decap_8
XFILLER_20_430 VPWR VGND sg13g2_decap_8
XFILLER_28_552 VPWR VGND sg13g2_decap_8
XFILLER_48_817 VPWR VGND sg13g2_decap_4
XFILLER_15_268 VPWR VGND sg13g2_decap_8
XFILLER_23_290 VPWR VGND sg13g2_decap_8
XFILLER_30_216 VPWR VGND sg13g2_decap_8
XFILLER_31_717 VPWR VGND sg13g2_decap_4
XFILLER_43_533 VPWR VGND sg13g2_decap_8
XFILLER_11_452 VPWR VGND sg13g2_decap_8
XFILLER_7_434 VPWR VGND sg13g2_decap_8
XFILLER_2_172 VPWR VGND sg13g2_decap_8
X_0490_ _0070_ _0277_ _0278_ net39 _0199_ VPWR VGND sg13g2_a22oi_1
XFILLER_0_42 VPWR VGND sg13g2_decap_8
XFILLER_19_574 VPWR VGND sg13g2_decap_8
XFILLER_34_522 VPWR VGND sg13g2_decap_8
XFILLER_46_371 VPWR VGND sg13g2_decap_8
X_1042_ state\[58\] net10 VPWR VGND sg13g2_buf_1
XFILLER_21_227 VPWR VGND sg13g2_decap_8
XFILLER_22_728 VPWR VGND sg13g2_decap_8
XFILLER_30_783 VPWR VGND sg13g2_decap_4
XFILLER_34_599 VPWR VGND sg13g2_decap_8
XFILLER_9_95 VPWR VGND sg13g2_decap_8
X_0826_ VPWR _0044_ state\[20\] VGND sg13g2_inv_1
X_0757_ _0370_ VPWR _0165_ VGND net90 _0027_ sg13g2_o21ai_1
X_0688_ _0249_ net70 _0426_ _0427_ VPWR VGND sg13g2_a21o_1
XFILLER_28_27 VPWR VGND sg13g2_decap_8
XFILLER_29_349 VPWR VGND sg13g2_decap_8
Xclkbuf_4_15_0_clk clknet_0_clk clknet_4_15_0_clk VPWR VGND sg13g2_buf_8
XFILLER_12_216 VPWR VGND sg13g2_decap_8
XFILLER_25_522 VPWR VGND sg13g2_decap_8
XFILLER_25_599 VPWR VGND sg13g2_decap_8
XFILLER_37_371 VPWR VGND sg13g2_decap_8
XFILLER_40_547 VPWR VGND sg13g2_decap_8
XFILLER_8_209 VPWR VGND sg13g2_decap_8
XFILLER_4_426 VPWR VGND sg13g2_decap_8
XFILLER_0_643 VPWR VGND sg13g2_fill_1
XFILLER_16_522 VPWR VGND sg13g2_decap_8
XFILLER_35_308 VPWR VGND sg13g2_decap_8
XFILLER_47_168 VPWR VGND sg13g2_decap_8
XFILLER_16_599 VPWR VGND sg13g2_decap_8
XFILLER_31_547 VPWR VGND sg13g2_decap_8
XFILLER_34_81 VPWR VGND sg13g2_decap_8
XFILLER_43_374 VPWR VGND sg13g2_decap_8
XFILLER_7_231 VPWR VGND sg13g2_decap_8
X_0611_ net90 VPWR _0369_ VGND net69 state\[37\] sg13g2_o21ai_1
X_0542_ _0083_ _0316_ _0317_ net43 _0212_ VPWR VGND sg13g2_a22oi_1
XFILLER_38_168 VPWR VGND sg13g2_decap_8
XFILLER_39_614 VPWR VGND sg13g2_fill_2
X_0473_ VGND VPWR net33 daisychain\[1\] _0266_ net37 sg13g2_a21oi_1
XFILLER_19_371 VPWR VGND sg13g2_decap_8
XFILLER_22_525 VPWR VGND sg13g2_decap_8
XFILLER_34_396 VPWR VGND sg13g2_decap_8
X_1025_ net119 VGND VPWR _0185_ state\[57\] clknet_5_26__leaf_clk sg13g2_dfrbpq_1
XFILLER_30_580 VPWR VGND sg13g2_decap_8
X_0809_ VPWR _0204_ daisychain\[11\] VGND sg13g2_inv_1
XFILLER_18_809 VPWR VGND sg13g2_decap_8
XFILLER_29_146 VPWR VGND sg13g2_decap_8
XFILLER_44_138 VPWR VGND sg13g2_decap_8
XFILLER_13_514 VPWR VGND sg13g2_decap_8
XFILLER_21_591 VPWR VGND sg13g2_decap_8
XFILLER_25_363 VPWR VGND sg13g2_decap_8
XFILLER_40_300 VPWR VGND sg13g2_decap_8
XFILLER_40_377 VPWR VGND sg13g2_decap_8
XFILLER_20_94 VPWR VGND sg13g2_decap_8
XFILLER_4_223 VPWR VGND sg13g2_decap_8
XFILLER_0_462 VPWR VGND sg13g2_decap_8
XFILLER_48_455 VPWR VGND sg13g2_decap_8
XFILLER_16_396 VPWR VGND sg13g2_decap_8
XFILLER_17_820 VPWR VGND sg13g2_fill_2
XFILLER_29_691 VPWR VGND sg13g2_decap_8
XFILLER_31_344 VPWR VGND sg13g2_decap_8
XFILLER_35_105 VPWR VGND sg13g2_decap_8
XFILLER_43_171 VPWR VGND sg13g2_decap_8
XANTENNA_1 VPWR VGND state\[20\] sg13g2_antennanp
XFILLER_8_584 VPWR VGND sg13g2_fill_2
XFILLER_8_573 VPWR VGND sg13g2_decap_8
X_0525_ VGND VPWR net27 daisychain\[14\] _0305_ net46 sg13g2_a21oi_1
X_0456_ VPWR _0021_ state\[61\] VGND sg13g2_inv_1
XFILLER_6_74 VPWR VGND sg13g2_decap_8
XFILLER_26_138 VPWR VGND sg13g2_decap_8
XFILLER_39_455 VPWR VGND sg13g2_decap_8
XFILLER_10_517 VPWR VGND sg13g2_decap_8
XFILLER_22_322 VPWR VGND sg13g2_decap_8
XFILLER_22_399 VPWR VGND sg13g2_decap_8
XFILLER_34_193 VPWR VGND sg13g2_decap_8
XFILLER_41_108 VPWR VGND sg13g2_decap_8
XFILLER_41_38 VPWR VGND sg13g2_decap_8
X_1008_ net115 VGND VPWR _0168_ state\[40\] clknet_5_22__leaf_clk sg13g2_dfrbpq_1
XFILLER_1_259 VPWR VGND sg13g2_decap_8
XFILLER_13_300 VPWR VGND sg13g2_decap_8
XFILLER_17_127 VPWR VGND sg13g2_decap_8
XFILLER_25_160 VPWR VGND sg13g2_decap_8
XFILLER_41_642 VPWR VGND sg13g2_decap_8
XFILLER_45_414 VPWR VGND sg13g2_decap_8
XFILLER_13_377 VPWR VGND sg13g2_decap_8
XFILLER_15_72 VPWR VGND sg13g2_decap_8
XFILLER_31_71 VPWR VGND sg13g2_decap_8
XFILLER_40_152 VPWR VGND sg13g2_fill_2
XFILLER_9_326 VPWR VGND sg13g2_decap_8
XFILLER_5_543 VPWR VGND sg13g2_fill_2
XFILLER_24_609 VPWR VGND sg13g2_decap_8
XFILLER_36_469 VPWR VGND sg13g2_decap_8
XFILLER_49_764 VPWR VGND sg13g2_decap_4
XFILLER_48_252 VPWR VGND sg13g2_decap_8
XFILLER_16_193 VPWR VGND sg13g2_decap_8
XFILLER_17_661 VPWR VGND sg13g2_fill_1
XFILLER_17_694 VPWR VGND sg13g2_fill_2
XFILLER_23_108 VPWR VGND sg13g2_decap_8
XFILLER_31_141 VPWR VGND sg13g2_decap_8
XFILLER_32_620 VPWR VGND sg13g2_decap_8
XFILLER_44_480 VPWR VGND sg13g2_decap_8
XFILLER_8_370 VPWR VGND sg13g2_decap_8
XFILLER_39_252 VPWR VGND sg13g2_decap_8
X_0508_ _0204_ net61 _0291_ _0292_ VPWR VGND sg13g2_a21o_1
XFILLER_27_469 VPWR VGND sg13g2_decap_8
XFILLER_36_49 VPWR VGND sg13g2_decap_8
XFILLER_42_406 VPWR VGND sg13g2_decap_8
XFILLER_10_314 VPWR VGND sg13g2_decap_8
XFILLER_22_196 VPWR VGND sg13g2_decap_8
XFILLER_23_675 VPWR VGND sg13g2_decap_8
XFILLER_2_557 VPWR VGND sg13g2_decap_8
XFILLER_18_447 VPWR VGND sg13g2_decap_8
XFILLER_45_211 VPWR VGND sg13g2_decap_8
XFILLER_46_712 VPWR VGND sg13g2_fill_1
XFILLER_13_174 VPWR VGND sg13g2_decap_8
XFILLER_14_653 VPWR VGND sg13g2_fill_2
XFILLER_26_82 VPWR VGND sg13g2_decap_8
XFILLER_33_417 VPWR VGND sg13g2_decap_8
XFILLER_41_461 VPWR VGND sg13g2_decap_8
XFILLER_45_288 VPWR VGND sg13g2_decap_8
XFILLER_9_123 VPWR VGND sg13g2_decap_8
X_0790_ VPWR _0054_ state\[2\] VGND sg13g2_inv_1
XFILLER_5_340 VPWR VGND sg13g2_decap_8
XFILLER_3_53 VPWR VGND sg13g2_decap_8
XFILLER_49_550 VPWR VGND sg13g2_decap_8
XFILLER_17_491 VPWR VGND sg13g2_decap_8
XFILLER_24_406 VPWR VGND sg13g2_decap_8
XFILLER_36_266 VPWR VGND sg13g2_decap_8
XFILLER_37_712 VPWR VGND sg13g2_fill_1
XFILLER_37_778 VPWR VGND sg13g2_fill_1
XFILLER_20_612 VPWR VGND sg13g2_decap_8
XFILLER_20_689 VPWR VGND sg13g2_decap_8
XFILLER_32_494 VPWR VGND sg13g2_decap_8
X_0988_ net110 VGND VPWR _0148_ state\[20\] clknet_5_20__leaf_clk sg13g2_dfrbpq_1
Xfanout102 net119 net102 VPWR VGND sg13g2_buf_1
Xfanout113 net118 net113 VPWR VGND sg13g2_buf_1
XFILLER_28_712 VPWR VGND sg13g2_decap_8
XFILLER_23_472 VPWR VGND sg13g2_decap_8
XFILLER_27_266 VPWR VGND sg13g2_decap_8
XFILLER_42_203 VPWR VGND sg13g2_decap_8
Xdigitalen0.g\[1\].u.inv2 VPWR digitalen0.g\[1\].u.OUTP digitalen0.g\[1\].u.OUTN VGND
+ sg13g2_inv_1
XFILLER_10_111 VPWR VGND sg13g2_decap_8
XFILLER_10_188 VPWR VGND sg13g2_decap_8
XFILLER_12_62 VPWR VGND sg13g2_decap_8
XFILLER_7_605 VPWR VGND sg13g2_decap_4
XFILLER_6_137 VPWR VGND sg13g2_decap_8
XFILLER_2_354 VPWR VGND sg13g2_decap_8
XFILLER_18_244 VPWR VGND sg13g2_decap_8
XFILLER_19_767 VPWR VGND sg13g2_fill_2
XFILLER_33_214 VPWR VGND sg13g2_decap_8
XFILLER_37_70 VPWR VGND sg13g2_decap_8
XFILLER_46_553 VPWR VGND sg13g2_decap_8
XFILLER_21_409 VPWR VGND sg13g2_decap_8
X_0911_ net103 VGND VPWR _0071_ daisychain\[7\] clknet_5_15__leaf_clk sg13g2_dfrbpq_1
X_0842_ VPWR _0052_ state\[28\] VGND sg13g2_inv_1
X_0773_ _0418_ VPWR _0181_ VGND net92 _0013_ sg13g2_o21ai_1
XFILLER_24_203 VPWR VGND sg13g2_decap_8
XFILLER_25_704 VPWR VGND sg13g2_decap_8
XFILLER_33_39 VPWR VGND sg13g2_decap_8
XFILLER_33_770 VPWR VGND sg13g2_decap_8
XFILLER_33_781 VPWR VGND sg13g2_fill_2
XFILLER_33_792 VPWR VGND sg13g2_fill_2
XFILLER_37_553 VPWR VGND sg13g2_decap_8
XFILLER_40_707 VPWR VGND sg13g2_fill_1
XFILLER_20_486 VPWR VGND sg13g2_decap_8
XFILLER_32_291 VPWR VGND sg13g2_decap_8
Xdigitalen1.g\[3\].u.inv1 VPWR digitalen1.g\[3\].u.OUTN net7 VGND sg13g2_inv_1
XFILLER_28_531 VPWR VGND sg13g2_decap_8
XFILLER_43_512 VPWR VGND sg13g2_decap_8
XFILLER_11_431 VPWR VGND sg13g2_decap_8
XFILLER_15_247 VPWR VGND sg13g2_decap_8
XFILLER_24_781 VPWR VGND sg13g2_decap_4
XFILLER_43_589 VPWR VGND sg13g2_fill_1
XFILLER_7_413 VPWR VGND sg13g2_decap_8
XFILLER_23_94 VPWR VGND sg13g2_decap_8
XFILLER_2_151 VPWR VGND sg13g2_decap_8
XFILLER_48_91 VPWR VGND sg13g2_decap_8
XFILLER_0_21 VPWR VGND sg13g2_decap_8
XFILLER_0_98 VPWR VGND sg13g2_decap_8
XFILLER_19_553 VPWR VGND sg13g2_decap_8
XFILLER_21_206 VPWR VGND sg13g2_decap_8
XFILLER_34_501 VPWR VGND sg13g2_decap_8
XFILLER_34_578 VPWR VGND sg13g2_decap_8
XFILLER_46_350 VPWR VGND sg13g2_decap_8
X_1041_ state\[57\] net9 VPWR VGND sg13g2_buf_1
X_0825_ VPWR _0212_ daisychain\[19\] VGND sg13g2_inv_1
XFILLER_9_74 VPWR VGND sg13g2_decap_8
X_0756_ _0367_ VPWR _0164_ VGND net92 _0026_ sg13g2_o21ai_1
X_0687_ net92 VPWR _0426_ VGND net70 state\[56\] sg13g2_o21ai_1
XFILLER_25_501 VPWR VGND sg13g2_decap_8
XFILLER_29_328 VPWR VGND sg13g2_decap_8
XFILLER_37_350 VPWR VGND sg13g2_decap_8
XFILLER_21_740 VPWR VGND sg13g2_fill_1
XFILLER_25_578 VPWR VGND sg13g2_decap_8
XFILLER_40_526 VPWR VGND sg13g2_decap_8
XFILLER_20_283 VPWR VGND sg13g2_decap_8
XFILLER_4_405 VPWR VGND sg13g2_decap_8
XFILLER_0_600 VPWR VGND sg13g2_decap_8
XFILLER_0_677 VPWR VGND sg13g2_decap_8
XFILLER_16_501 VPWR VGND sg13g2_decap_8
XFILLER_16_578 VPWR VGND sg13g2_decap_8
XFILLER_18_83 VPWR VGND sg13g2_decap_8
XFILLER_31_526 VPWR VGND sg13g2_decap_8
XFILLER_43_353 VPWR VGND sg13g2_decap_8
XFILLER_47_147 VPWR VGND sg13g2_decap_8
XFILLER_34_60 VPWR VGND sg13g2_decap_8
XFILLER_8_733 VPWR VGND sg13g2_decap_4
XFILLER_7_210 VPWR VGND sg13g2_decap_8
X_0610_ _0100_ _0367_ _0368_ net48 _0229_ VPWR VGND sg13g2_a22oi_1
X_0541_ VGND VPWR net26 daisychain\[18\] _0317_ net43 sg13g2_a21oi_1
X_0472_ _0195_ net77 _0264_ _0265_ VPWR VGND sg13g2_a21o_1
XFILLER_7_287 VPWR VGND sg13g2_decap_8
XFILLER_19_350 VPWR VGND sg13g2_decap_8
XFILLER_22_4 VPWR VGND sg13g2_decap_4
XFILLER_35_821 VPWR VGND sg13g2_fill_2
XFILLER_38_147 VPWR VGND sg13g2_decap_8
XFILLER_47_670 VPWR VGND sg13g2_fill_1
X_1024_ net112 VGND VPWR _0184_ state\[56\] clknet_5_27__leaf_clk sg13g2_dfrbpq_1
XFILLER_22_504 VPWR VGND sg13g2_decap_8
XFILLER_34_375 VPWR VGND sg13g2_decap_8
X_0808_ VPWR _0034_ state\[11\] VGND sg13g2_inv_1
XFILLER_29_125 VPWR VGND sg13g2_decap_8
XFILLER_39_49 VPWR VGND sg13g2_decap_8
X_0739_ _0316_ VPWR _0147_ VGND net87 _0042_ sg13g2_o21ai_1
XFILLER_17_309 VPWR VGND sg13g2_decap_8
XFILLER_25_342 VPWR VGND sg13g2_decap_8
XFILLER_26_821 VPWR VGND sg13g2_fill_2
XFILLER_44_117 VPWR VGND sg13g2_decap_8
XFILLER_21_570 VPWR VGND sg13g2_decap_8
XFILLER_40_356 VPWR VGND sg13g2_decap_8
XFILLER_9_519 VPWR VGND sg13g2_fill_2
XFILLER_9_508 VPWR VGND sg13g2_decap_8
XFILLER_20_73 VPWR VGND sg13g2_decap_8
XFILLER_4_279 VPWR VGND sg13g2_decap_8
XFILLER_4_202 VPWR VGND sg13g2_decap_8
XFILLER_0_441 VPWR VGND sg13g2_decap_8
XFILLER_29_670 VPWR VGND sg13g2_decap_8
XFILLER_48_434 VPWR VGND sg13g2_decap_8
XFILLER_16_375 VPWR VGND sg13g2_decap_8
XFILLER_31_323 VPWR VGND sg13g2_decap_8
XFILLER_43_150 VPWR VGND sg13g2_decap_8
XFILLER_44_640 VPWR VGND sg13g2_decap_8
XFILLER_44_651 VPWR VGND sg13g2_fill_1
XFILLER_44_695 VPWR VGND sg13g2_fill_1
XFILLER_45_92 VPWR VGND sg13g2_decap_8
XANTENNA_2 VPWR VGND state\[20\] sg13g2_antennanp
XFILLER_12_592 VPWR VGND sg13g2_decap_8
Xclkbuf_4_14_0_clk clknet_0_clk clknet_4_14_0_clk VPWR VGND sg13g2_buf_8
XFILLER_8_552 VPWR VGND sg13g2_decap_8
XFILLER_6_53 VPWR VGND sg13g2_decap_8
XFILLER_39_434 VPWR VGND sg13g2_decap_8
X_0524_ _0208_ net64 _0303_ _0304_ VPWR VGND sg13g2_a21o_1
X_0455_ VPWR _0253_ daisychain\[60\] VGND sg13g2_inv_1
XFILLER_22_301 VPWR VGND sg13g2_decap_8
XFILLER_26_117 VPWR VGND sg13g2_decap_8
X_1007_ net116 VGND VPWR _0167_ state\[39\] clknet_5_29__leaf_clk sg13g2_dfrbpq_1
XFILLER_22_378 VPWR VGND sg13g2_decap_8
XFILLER_34_172 VPWR VGND sg13g2_decap_8
XFILLER_1_238 VPWR VGND sg13g2_decap_8
XFILLER_17_106 VPWR VGND sg13g2_decap_8
XFILLER_18_629 VPWR VGND sg13g2_decap_8
XFILLER_13_356 VPWR VGND sg13g2_decap_8
XFILLER_15_51 VPWR VGND sg13g2_decap_8
XFILLER_26_684 VPWR VGND sg13g2_decap_8
XFILLER_32_109 VPWR VGND sg13g2_decap_8
XFILLER_40_131 VPWR VGND sg13g2_decap_8
XFILLER_41_621 VPWR VGND sg13g2_decap_8
XFILLER_9_305 VPWR VGND sg13g2_decap_8
XFILLER_5_522 VPWR VGND sg13g2_decap_8
XFILLER_5_577 VPWR VGND sg13g2_decap_8
XFILLER_49_721 VPWR VGND sg13g2_fill_2
XFILLER_49_710 VPWR VGND sg13g2_decap_8
XFILLER_36_448 VPWR VGND sg13g2_decap_8
XFILLER_48_231 VPWR VGND sg13g2_decap_8
XFILLER_16_172 VPWR VGND sg13g2_decap_8
XFILLER_31_120 VPWR VGND sg13g2_decap_8
XFILLER_31_197 VPWR VGND sg13g2_decap_8
XFILLER_32_676 VPWR VGND sg13g2_decap_8
XFILLER_32_698 VPWR VGND sg13g2_fill_2
XFILLER_36_28 VPWR VGND sg13g2_decap_8
XFILLER_39_231 VPWR VGND sg13g2_decap_8
X_0507_ net82 VPWR _0291_ VGND net61 state\[11\] sg13g2_o21ai_1
XFILLER_23_654 VPWR VGND sg13g2_decap_8
XFILLER_27_448 VPWR VGND sg13g2_decap_8
XFILLER_22_175 VPWR VGND sg13g2_decap_8
XFILLER_6_319 VPWR VGND sg13g2_decap_8
XFILLER_2_536 VPWR VGND sg13g2_decap_8
XFILLER_18_426 VPWR VGND sg13g2_decap_8
XFILLER_45_267 VPWR VGND sg13g2_decap_8
XFILLER_13_153 VPWR VGND sg13g2_decap_8
XFILLER_14_676 VPWR VGND sg13g2_decap_4
XFILLER_26_481 VPWR VGND sg13g2_decap_8
XFILLER_26_61 VPWR VGND sg13g2_decap_8
XFILLER_41_440 VPWR VGND sg13g2_decap_8
XFILLER_9_102 VPWR VGND sg13g2_decap_8
XFILLER_42_82 VPWR VGND sg13g2_decap_8
XFILLER_9_179 VPWR VGND sg13g2_decap_8
XFILLER_5_396 VPWR VGND sg13g2_decap_8
XFILLER_3_32 VPWR VGND sg13g2_decap_8
XFILLER_17_470 VPWR VGND sg13g2_decap_8
XFILLER_36_245 VPWR VGND sg13g2_decap_8
XFILLER_20_668 VPWR VGND sg13g2_decap_8
XFILLER_32_473 VPWR VGND sg13g2_decap_8
X_0987_ net110 VGND VPWR _0147_ state\[19\] clknet_5_3__leaf_clk sg13g2_dfrbpq_1
Xclkbuf_5_28__f_clk clknet_5_28__leaf_clk clknet_4_14_0_clk VPWR VGND sg13g2_buf_16
Xfanout103 net105 net103 VPWR VGND sg13g2_buf_1
Xfanout114 net115 net114 VPWR VGND sg13g2_buf_1
XFILLER_27_245 VPWR VGND sg13g2_decap_8
XFILLER_28_757 VPWR VGND sg13g2_fill_1
XFILLER_28_768 VPWR VGND sg13g2_decap_8
XFILLER_47_49 VPWR VGND sg13g2_decap_8
XFILLER_15_429 VPWR VGND sg13g2_decap_8
XFILLER_23_451 VPWR VGND sg13g2_decap_8
XFILLER_36_790 VPWR VGND sg13g2_fill_2
XFILLER_42_259 VPWR VGND sg13g2_decap_8
XFILLER_10_167 VPWR VGND sg13g2_decap_8
XFILLER_12_41 VPWR VGND sg13g2_decap_8
XFILLER_6_116 VPWR VGND sg13g2_decap_8
XFILLER_19_724 VPWR VGND sg13g2_fill_2
XFILLER_2_333 VPWR VGND sg13g2_decap_8
XFILLER_18_223 VPWR VGND sg13g2_decap_8
XFILLER_46_532 VPWR VGND sg13g2_decap_8
XFILLER_14_495 VPWR VGND sg13g2_decap_8
X_0910_ net103 VGND VPWR _0070_ daisychain\[6\] clknet_5_12__leaf_clk sg13g2_dfrbpq_1
X_0841_ VPWR _0220_ daisychain\[27\] VGND sg13g2_inv_1
X_0772_ _0415_ VPWR _0180_ VGND net91 _0012_ sg13g2_o21ai_1
XFILLER_5_193 VPWR VGND sg13g2_decap_8
XFILLER_37_532 VPWR VGND sg13g2_decap_8
XFILLER_24_259 VPWR VGND sg13g2_decap_8
XFILLER_32_270 VPWR VGND sg13g2_decap_8
XFILLER_33_18 VPWR VGND sg13g2_decap_8
XFILLER_20_465 VPWR VGND sg13g2_decap_8
Xdigitalen1.g\[3\].u.inv2 VPWR digitalen1.g\[3\].u.OUTP digitalen1.g\[3\].u.OUTN VGND
+ sg13g2_inv_1
XFILLER_0_804 VPWR VGND sg13g2_decap_8
XFILLER_47_329 VPWR VGND sg13g2_decap_8
XFILLER_15_226 VPWR VGND sg13g2_decap_8
XFILLER_28_510 VPWR VGND sg13g2_decap_8
XFILLER_28_587 VPWR VGND sg13g2_decap_8
XFILLER_43_568 VPWR VGND sg13g2_decap_8
XFILLER_11_410 VPWR VGND sg13g2_decap_8
XFILLER_11_498 VPWR VGND sg13g2_decap_8
XFILLER_23_73 VPWR VGND sg13g2_decap_8
XFILLER_2_130 VPWR VGND sg13g2_decap_8
XFILLER_7_469 VPWR VGND sg13g2_decap_8
XFILLER_19_532 VPWR VGND sg13g2_decap_8
XFILLER_38_329 VPWR VGND sg13g2_decap_8
X_1040_ state\[56\] net8 VPWR VGND sg13g2_buf_1
Xclkbuf_5_11__f_clk clknet_5_11__leaf_clk clknet_4_5_0_clk VPWR VGND sg13g2_buf_16
XFILLER_48_70 VPWR VGND sg13g2_decap_8
XFILLER_0_77 VPWR VGND sg13g2_decap_8
XFILLER_14_292 VPWR VGND sg13g2_decap_8
XFILLER_15_793 VPWR VGND sg13g2_fill_1
XFILLER_34_557 VPWR VGND sg13g2_decap_8
XFILLER_9_53 VPWR VGND sg13g2_decap_8
X_0824_ VPWR _0042_ state\[19\] VGND sg13g2_inv_1
X_0755_ _0364_ VPWR _0163_ VGND net90 _0025_ sg13g2_o21ai_1
XFILLER_6_480 VPWR VGND sg13g2_decap_8
XFILLER_29_307 VPWR VGND sg13g2_decap_8
XFILLER_43_0 VPWR VGND sg13g2_decap_8
X_0686_ _0119_ _0424_ _0425_ net48 _0248_ VPWR VGND sg13g2_a22oi_1
XFILLER_25_557 VPWR VGND sg13g2_decap_8
XFILLER_20_262 VPWR VGND sg13g2_decap_8
XFILLER_40_505 VPWR VGND sg13g2_decap_8
XFILLER_0_612 VPWR VGND sg13g2_fill_2
XFILLER_0_656 VPWR VGND sg13g2_decap_8
XFILLER_18_62 VPWR VGND sg13g2_decap_8
XFILLER_47_126 VPWR VGND sg13g2_decap_8
XFILLER_48_627 VPWR VGND sg13g2_fill_1
XFILLER_48_616 VPWR VGND sg13g2_decap_8
XFILLER_16_557 VPWR VGND sg13g2_decap_8
XFILLER_28_384 VPWR VGND sg13g2_decap_8
XFILLER_31_505 VPWR VGND sg13g2_decap_8
XFILLER_43_332 VPWR VGND sg13g2_decap_8
XFILLER_11_284 VPWR VGND sg13g2_decap_8
XFILLER_7_266 VPWR VGND sg13g2_decap_8
XFILLER_39_616 VPWR VGND sg13g2_fill_1
XFILLER_3_494 VPWR VGND sg13g2_decap_8
X_0540_ _0212_ net65 _0315_ _0316_ VPWR VGND sg13g2_a21o_1
X_0471_ net99 VPWR _0264_ VGND net77 state\[2\] sg13g2_o21ai_1
XFILLER_38_126 VPWR VGND sg13g2_decap_8
X_1023_ net112 VGND VPWR _0183_ state\[55\] clknet_5_27__leaf_clk sg13g2_dfrbpq_1
XFILLER_15_590 VPWR VGND sg13g2_decap_8
XFILLER_34_354 VPWR VGND sg13g2_decap_8
X_0807_ VPWR _0203_ daisychain\[10\] VGND sg13g2_inv_1
X_0738_ _0313_ VPWR _0146_ VGND net87 _0041_ sg13g2_o21ai_1
XFILLER_29_104 VPWR VGND sg13g2_decap_8
XFILLER_39_28 VPWR VGND sg13g2_decap_8
X_0669_ VGND VPWR net30 daisychain\[50\] _0413_ net52 sg13g2_a21oi_1
XFILLER_13_549 VPWR VGND sg13g2_decap_8
XFILLER_25_321 VPWR VGND sg13g2_decap_8
XFILLER_25_398 VPWR VGND sg13g2_decap_8
XFILLER_40_335 VPWR VGND sg13g2_decap_8
XFILLER_0_420 VPWR VGND sg13g2_decap_8
XFILLER_20_52 VPWR VGND sg13g2_decap_8
XFILLER_4_258 VPWR VGND sg13g2_decap_8
XFILLER_0_497 VPWR VGND sg13g2_decap_8
XFILLER_17_822 VPWR VGND sg13g2_fill_1
XFILLER_28_181 VPWR VGND sg13g2_decap_8
XFILLER_29_83 VPWR VGND sg13g2_decap_8
XFILLER_48_413 VPWR VGND sg13g2_decap_8
XFILLER_12_571 VPWR VGND sg13g2_decap_8
XFILLER_16_354 VPWR VGND sg13g2_decap_8
XFILLER_31_302 VPWR VGND sg13g2_decap_8
XFILLER_31_379 VPWR VGND sg13g2_decap_8
XFILLER_45_71 VPWR VGND sg13g2_decap_8
XFILLER_8_531 VPWR VGND sg13g2_decap_8
XANTENNA_3 VPWR VGND state\[20\] sg13g2_antennanp
Xclkbuf_5_9__f_clk clknet_5_9__leaf_clk clknet_4_4_0_clk VPWR VGND sg13g2_buf_16
XFILLER_6_32 VPWR VGND sg13g2_decap_8
XFILLER_39_413 VPWR VGND sg13g2_decap_8
XFILLER_3_291 VPWR VGND sg13g2_decap_8
X_0523_ net85 VPWR _0303_ VGND net64 state\[15\] sg13g2_o21ai_1
X_0454_ VPWR _0020_ state\[60\] VGND sg13g2_inv_1
XFILLER_23_814 VPWR VGND sg13g2_decap_8
XFILLER_34_151 VPWR VGND sg13g2_decap_8
XFILLER_35_630 VPWR VGND sg13g2_decap_8
XFILLER_47_490 VPWR VGND sg13g2_decap_8
X_1006_ net116 VGND VPWR _0166_ state\[38\] clknet_5_29__leaf_clk sg13g2_dfrbpq_1
XFILLER_22_357 VPWR VGND sg13g2_decap_8
XFILLER_1_217 VPWR VGND sg13g2_decap_8
XFILLER_18_608 VPWR VGND sg13g2_decap_8
XFILLER_38_490 VPWR VGND sg13g2_decap_8
XFILLER_45_449 VPWR VGND sg13g2_decap_8
XFILLER_13_335 VPWR VGND sg13g2_decap_8
XFILLER_25_195 VPWR VGND sg13g2_decap_8
XFILLER_26_663 VPWR VGND sg13g2_decap_8
XFILLER_40_110 VPWR VGND sg13g2_decap_8
XFILLER_5_545 VPWR VGND sg13g2_fill_1
XFILLER_5_501 VPWR VGND sg13g2_decap_8
XFILLER_0_294 VPWR VGND sg13g2_decap_8
XFILLER_48_210 VPWR VGND sg13g2_decap_8
XFILLER_16_151 VPWR VGND sg13g2_decap_8
XFILLER_17_652 VPWR VGND sg13g2_decap_8
XFILLER_36_427 VPWR VGND sg13g2_decap_8
XFILLER_49_788 VPWR VGND sg13g2_decap_4
XFILLER_48_287 VPWR VGND sg13g2_decap_8
XFILLER_20_806 VPWR VGND sg13g2_decap_8
XFILLER_31_176 VPWR VGND sg13g2_decap_8
XFILLER_32_655 VPWR VGND sg13g2_decap_8
X_0506_ _0074_ _0289_ _0290_ net41 _0203_ VPWR VGND sg13g2_a22oi_1
XFILLER_27_427 VPWR VGND sg13g2_decap_8
XFILLER_39_210 VPWR VGND sg13g2_decap_8
XFILLER_39_287 VPWR VGND sg13g2_decap_8
XFILLER_22_154 VPWR VGND sg13g2_decap_8
XFILLER_23_633 VPWR VGND sg13g2_decap_8
XFILLER_10_349 VPWR VGND sg13g2_decap_8
XFILLER_2_515 VPWR VGND sg13g2_decap_8
Xclkbuf_4_13_0_clk clknet_0_clk clknet_4_13_0_clk VPWR VGND sg13g2_buf_8
XFILLER_14_600 VPWR VGND sg13g2_decap_8
XFILLER_18_405 VPWR VGND sg13g2_decap_8
XFILLER_26_460 VPWR VGND sg13g2_decap_8
XFILLER_45_246 VPWR VGND sg13g2_decap_8
XFILLER_13_132 VPWR VGND sg13g2_decap_8
XFILLER_41_496 VPWR VGND sg13g2_decap_4
XFILLER_42_61 VPWR VGND sg13g2_decap_8
XFILLER_9_158 VPWR VGND sg13g2_decap_8
XFILLER_3_11 VPWR VGND sg13g2_decap_8
XFILLER_47_7 VPWR VGND sg13g2_decap_8
XFILLER_5_375 VPWR VGND sg13g2_decap_8
XFILLER_36_224 VPWR VGND sg13g2_decap_8
XFILLER_3_88 VPWR VGND sg13g2_decap_8
XFILLER_49_585 VPWR VGND sg13g2_decap_8
XFILLER_32_452 VPWR VGND sg13g2_decap_8
XFILLER_37_769 VPWR VGND sg13g2_decap_8
XFILLER_20_647 VPWR VGND sg13g2_decap_8
X_0986_ net108 VGND VPWR _0146_ state\[18\] clknet_5_1__leaf_clk sg13g2_dfrbpq_1
XFILLER_9_692 VPWR VGND sg13g2_decap_8
XFILLER_47_28 VPWR VGND sg13g2_decap_8
Xfanout104 net105 net104 VPWR VGND sg13g2_buf_1
Xfanout115 net117 net115 VPWR VGND sg13g2_buf_1
XFILLER_15_408 VPWR VGND sg13g2_decap_8
XFILLER_27_224 VPWR VGND sg13g2_decap_8
XFILLER_28_747 VPWR VGND sg13g2_fill_2
XFILLER_43_728 VPWR VGND sg13g2_decap_8
XFILLER_43_739 VPWR VGND sg13g2_fill_2
XFILLER_10_146 VPWR VGND sg13g2_decap_8
XFILLER_12_20 VPWR VGND sg13g2_decap_8
XFILLER_23_430 VPWR VGND sg13g2_decap_8
XFILLER_42_238 VPWR VGND sg13g2_decap_8
XFILLER_12_97 VPWR VGND sg13g2_decap_8
XFILLER_2_312 VPWR VGND sg13g2_decap_8
XFILLER_18_202 VPWR VGND sg13g2_decap_8
XFILLER_2_389 VPWR VGND sg13g2_decap_8
XFILLER_46_511 VPWR VGND sg13g2_decap_8
XFILLER_14_474 VPWR VGND sg13g2_decap_8
XFILLER_18_279 VPWR VGND sg13g2_decap_8
XFILLER_19_769 VPWR VGND sg13g2_fill_1
XFILLER_27_780 VPWR VGND sg13g2_fill_2
XFILLER_33_249 VPWR VGND sg13g2_decap_8
XFILLER_34_739 VPWR VGND sg13g2_fill_2
XFILLER_46_588 VPWR VGND sg13g2_decap_8
XFILLER_41_293 VPWR VGND sg13g2_decap_8
X_0840_ VPWR _0051_ state\[27\] VGND sg13g2_inv_1
X_0771_ _0412_ VPWR _0179_ VGND net91 _0010_ sg13g2_o21ai_1
XFILLER_6_695 VPWR VGND sg13g2_decap_4
XFILLER_5_172 VPWR VGND sg13g2_decap_8
XFILLER_25_739 VPWR VGND sg13g2_decap_4
XFILLER_37_511 VPWR VGND sg13g2_decap_8
XFILLER_37_588 VPWR VGND sg13g2_decap_8
XFILLER_49_382 VPWR VGND sg13g2_decap_8
XFILLER_20_444 VPWR VGND sg13g2_decap_8
XFILLER_24_238 VPWR VGND sg13g2_decap_8
XFILLER_3_109 VPWR VGND sg13g2_decap_8
X_0969_ net103 VGND VPWR _0129_ state\[1\] clknet_5_9__leaf_clk sg13g2_dfrbpq_1
XFILLER_47_308 VPWR VGND sg13g2_decap_8
XFILLER_15_205 VPWR VGND sg13g2_decap_8
XFILLER_28_566 VPWR VGND sg13g2_decap_8
XFILLER_43_547 VPWR VGND sg13g2_decap_8
XFILLER_11_466 VPWR VGND sg13g2_decap_8
XFILLER_11_477 VPWR VGND sg13g2_fill_1
XFILLER_7_448 VPWR VGND sg13g2_decap_8
XFILLER_2_186 VPWR VGND sg13g2_decap_8
XFILLER_0_56 VPWR VGND sg13g2_decap_8
XFILLER_19_511 VPWR VGND sg13g2_decap_8
XFILLER_19_588 VPWR VGND sg13g2_decap_8
XFILLER_38_308 VPWR VGND sg13g2_decap_8
XFILLER_46_385 VPWR VGND sg13g2_decap_8
XFILLER_14_271 VPWR VGND sg13g2_decap_8
XFILLER_15_761 VPWR VGND sg13g2_fill_1
XFILLER_30_720 VPWR VGND sg13g2_decap_8
XFILLER_34_536 VPWR VGND sg13g2_decap_8
XFILLER_9_32 VPWR VGND sg13g2_decap_8
X_0823_ VPWR _0211_ daisychain\[18\] VGND sg13g2_inv_1
X_0754_ _0361_ VPWR _0162_ VGND net90 _0022_ sg13g2_o21ai_1
X_0685_ VGND VPWR net31 daisychain\[54\] _0425_ net48 sg13g2_a21oi_1
XFILLER_36_0 VPWR VGND sg13g2_decap_8
XFILLER_25_536 VPWR VGND sg13g2_decap_8
XFILLER_37_385 VPWR VGND sg13g2_decap_8
XFILLER_20_241 VPWR VGND sg13g2_decap_8
XFILLER_0_624 VPWR VGND sg13g2_decap_8
XFILLER_18_41 VPWR VGND sg13g2_decap_8
XFILLER_28_363 VPWR VGND sg13g2_decap_8
XFILLER_47_105 VPWR VGND sg13g2_decap_8
XFILLER_48_639 VPWR VGND sg13g2_decap_4
XFILLER_16_536 VPWR VGND sg13g2_decap_8
XFILLER_34_95 VPWR VGND sg13g2_decap_8
XFILLER_43_311 VPWR VGND sg13g2_decap_8
XFILLER_43_388 VPWR VGND sg13g2_decap_8
XFILLER_11_263 VPWR VGND sg13g2_decap_8
XFILLER_7_245 VPWR VGND sg13g2_decap_8
XFILLER_38_105 VPWR VGND sg13g2_decap_8
XFILLER_3_473 VPWR VGND sg13g2_decap_8
X_0470_ _0065_ _0262_ _0263_ net56 _0194_ VPWR VGND sg13g2_a22oi_1
XFILLER_19_385 VPWR VGND sg13g2_decap_8
XFILLER_34_333 VPWR VGND sg13g2_decap_8
XFILLER_46_182 VPWR VGND sg13g2_decap_8
XFILLER_47_661 VPWR VGND sg13g2_decap_8
XFILLER_47_683 VPWR VGND sg13g2_fill_1
XFILLER_47_694 VPWR VGND sg13g2_fill_2
X_1022_ net113 VGND VPWR _0182_ state\[54\] clknet_5_28__leaf_clk sg13g2_dfrbpq_1
XFILLER_22_539 VPWR VGND sg13g2_decap_8
XFILLER_30_594 VPWR VGND sg13g2_decap_8
X_0806_ VPWR _0033_ state\[10\] VGND sg13g2_inv_1
X_0737_ _0310_ VPWR _0145_ VGND net86 _0040_ sg13g2_o21ai_1
X_0668_ _0244_ net74 _0411_ _0412_ VPWR VGND sg13g2_a21o_1
XFILLER_25_300 VPWR VGND sg13g2_decap_8
X_0599_ net90 VPWR _0360_ VGND net69 state\[34\] sg13g2_o21ai_1
XFILLER_13_528 VPWR VGND sg13g2_decap_8
XFILLER_25_377 VPWR VGND sg13g2_decap_8
XFILLER_37_182 VPWR VGND sg13g2_decap_8
XFILLER_38_694 VPWR VGND sg13g2_decap_4
XFILLER_40_314 VPWR VGND sg13g2_decap_8
XFILLER_20_20 VPWR VGND sg13g2_fill_1
XFILLER_20_31 VPWR VGND sg13g2_decap_8
XFILLER_4_237 VPWR VGND sg13g2_decap_8
XFILLER_0_476 VPWR VGND sg13g2_decap_8
XFILLER_29_62 VPWR VGND sg13g2_decap_8
XFILLER_16_333 VPWR VGND sg13g2_decap_8
XFILLER_28_160 VPWR VGND sg13g2_decap_8
XFILLER_35_119 VPWR VGND sg13g2_decap_8
XFILLER_36_609 VPWR VGND sg13g2_decap_8
XFILLER_45_50 VPWR VGND sg13g2_decap_8
XFILLER_48_469 VPWR VGND sg13g2_decap_8
XFILLER_12_550 VPWR VGND sg13g2_decap_8
XFILLER_31_358 VPWR VGND sg13g2_decap_8
XFILLER_43_185 VPWR VGND sg13g2_decap_8
XFILLER_8_510 VPWR VGND sg13g2_decap_8
XFILLER_3_270 VPWR VGND sg13g2_decap_8
X_0522_ _0078_ _0301_ _0302_ net46 _0207_ VPWR VGND sg13g2_a22oi_1
XFILLER_6_88 VPWR VGND sg13g2_decap_8
XFILLER_6_11 VPWR VGND sg13g2_decap_8
XFILLER_27_609 VPWR VGND sg13g2_decap_8
XFILLER_39_469 VPWR VGND sg13g2_decap_8
X_0453_ VPWR _0252_ daisychain\[59\] VGND sg13g2_inv_1
XFILLER_19_182 VPWR VGND sg13g2_decap_8
XFILLER_22_336 VPWR VGND sg13g2_decap_8
XFILLER_34_130 VPWR VGND sg13g2_decap_8
X_1005_ net111 VGND VPWR _0165_ state\[37\] clknet_5_28__leaf_clk sg13g2_dfrbpq_1
XFILLER_30_391 VPWR VGND sg13g2_decap_8
XFILLER_26_642 VPWR VGND sg13g2_decap_8
XFILLER_45_428 VPWR VGND sg13g2_decap_8
XFILLER_13_314 VPWR VGND sg13g2_decap_8
XFILLER_15_86 VPWR VGND sg13g2_decap_8
XFILLER_25_174 VPWR VGND sg13g2_decap_8
XFILLER_40_188 VPWR VGND sg13g2_decap_8
XFILLER_31_85 VPWR VGND sg13g2_decap_8
XFILLER_0_273 VPWR VGND sg13g2_decap_8
XFILLER_1_785 VPWR VGND sg13g2_fill_2
XFILLER_36_406 VPWR VGND sg13g2_decap_8
XFILLER_48_266 VPWR VGND sg13g2_decap_8
XFILLER_16_130 VPWR VGND sg13g2_decap_8
XFILLER_17_631 VPWR VGND sg13g2_decap_8
XFILLER_32_634 VPWR VGND sg13g2_decap_8
XFILLER_44_494 VPWR VGND sg13g2_decap_8
XFILLER_31_155 VPWR VGND sg13g2_decap_8
XFILLER_8_384 VPWR VGND sg13g2_decap_8
X_0505_ VGND VPWR net27 daisychain\[9\] _0290_ net41 sg13g2_a21oi_1
.ends

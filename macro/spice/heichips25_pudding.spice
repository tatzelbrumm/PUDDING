* NGSPICE file created from heichips25_pudding.ext - technology: ihp-sg13g2

* Black-box entry subcircuit for sg13g2_decap_8 abstract view
.subckt sg13g2_decap_8 VDD VSS
.ends

* Black-box entry subcircuit for sg13g2_dfrbpq_1 abstract view
.subckt sg13g2_dfrbpq_1 RESET_B VSS VDD D Q CLK
.ends

* Black-box entry subcircuit for sg13g2_decap_4 abstract view
.subckt sg13g2_decap_4 VDD VSS
.ends

* Black-box entry subcircuit for sg13g2_a21oi_1 abstract view
.subckt sg13g2_a21oi_1 VSS VDD A1 A2 Y B1
.ends

* Black-box entry subcircuit for sg13g2_fill_2 abstract view
.subckt sg13g2_fill_2 VDD VSS
.ends

* Black-box entry subcircuit for sg13g2_inv_1 abstract view
.subckt sg13g2_inv_1 VDD Y A VSS
.ends

* Black-box entry subcircuit for sg13g2_fill_1 abstract view
.subckt sg13g2_fill_1 VDD VSS
.ends

* Black-box entry subcircuit for sg13g2_buf_1 abstract view
.subckt sg13g2_buf_1 A X VDD VSS
.ends

* Black-box entry subcircuit for sg13g2_a21o_1 abstract view
.subckt sg13g2_a21o_1 A2 A1 B1 X VDD VSS
.ends

* Black-box entry subcircuit for sg13g2_o21ai_1 abstract view
.subckt sg13g2_o21ai_1 B1 VDD Y VSS A1 A2
.ends

* Black-box entry subcircuit for sg13g2_a22oi_1 abstract view
.subckt sg13g2_a22oi_1 Y B1 B2 A2 A1 VDD VSS
.ends

* Black-box entry subcircuit for sg13g2_buf_8 abstract view
.subckt sg13g2_buf_8 A X VDD VSS
.ends

* Black-box entry subcircuit for sg13g2_inv_2 abstract view
.subckt sg13g2_inv_2 Y A VDD VSS
.ends

* Black-box entry subcircuit for sg13g2_buf_16 abstract view
.subckt sg13g2_buf_16 X A VDD VSS
.ends

* Black-box entry subcircuit for sg13g2_inv_8 abstract view
.subckt sg13g2_inv_8 Y A VDD VSS
.ends

* Black-box entry subcircuit for sg13g2_inv_16 abstract view
.subckt sg13g2_inv_16 A Y VDD VSS
.ends

* Black-box entry subcircuit for sg13g2_inv_4 abstract view
.subckt sg13g2_inv_4 A Y VDD VSS
.ends

* Black-box entry subcircuit for input_mirror abstract view
.subckt input_mirror VSSA i_out VbiasP[0] VbiasP[1] VbiasP[2] VbiasP[3] VbiasP[4]
+ VbiasP[5] VbiasP[6] VbiasP[7] i_in
.ends

* Black-box entry subcircuit for sg13g2_nor2_1 abstract view
.subckt sg13g2_nor2_1 A B Y VDD VSS
.ends

* Black-box entry subcircuit for dac4x32module abstract view
.subckt dac4x32module EN[13] ENB[13] ON[111] ONB[111] ON[110] ONB[110] ON[109] ONB[109]
+ ON[108] ONB[108] ON[107] ONB[107] ON[106] ONB[106] ON[105] ONB[105] ON[104] ONB[104]
+ ON[103] ONB[103] ON[102] ONB[102] ON[101] ONB[101] ON[100] ONB[100] ON[99] ONB[99]
+ ON[98] ONB[98] ON[97] ONB[97] ON[96] ONB[96] EN[12] ENB[12] EN[15] ENB[15] ON[127]
+ ONB[127] ON[126] ONB[126] ON[125] ONB[125] ON[124] ONB[124] ON[123] ONB[123] ON[122]
+ ONB[122] ON[121] ONB[121] ON[120] ONB[120] ON[119] ONB[119] ON[118] ONB[118] ON[117]
+ ONB[117] ON[116] ONB[116] ON[115] ONB[115] ON[114] ONB[114] ON[113] ONB[113] ON[112]
+ ONB[112] EN[14] ENB[14] EN[9] ENB[9] ON[79] ONB[79] ON[78] ONB[78] ON[77] ONB[77]
+ ON[76] ONB[76] ON[75] ONB[75] ON[74] ONB[74] ON[73] ONB[73] ON[72] ONB[72] ON[71]
+ ONB[71] ON[70] ONB[70] ON[69] ONB[69] ON[68] ONB[68] ON[67] ONB[67] ON[66] ONB[66]
+ ON[65] ONB[65] ON[64] ONB[64] EN[8] ENB[8] EN[11] ENB[11] ON[95] ONB[95] ON[94]
+ ONB[94] ON[93] ONB[93] ON[92] ONB[92] ON[91] ONB[91] ON[90] ONB[90] ON[89] ONB[89]
+ ON[88] ONB[88] ON[87] ONB[87] ON[86] ONB[86] ON[85] ONB[85] ON[84] ONB[84] ON[83]
+ ONB[83] ON[82] ONB[82] ON[81] ONB[81] ON[80] ONB[80] EN[10] ENB[10] EN[4] ENB[4]
+ EN[6] ENB[6] ON[63] ONB[63] ON[62] ONB[62] ON[61] ONB[61] ON[60] ONB[60] ON[59]
+ ONB[59] ON[58] ONB[58] ON[57] EN[7] ENB[7] ONB[57] ON[56] ONB[56] ON[55] ONB[55]
+ ON[54] ONB[54] ON[53] ONB[53] ON[52] ONB[52] ON[51] ONB[51] ON[50] ONB[50] ON[49]
+ ONB[49] ON[48] ONB[48] ON[47] ONB[47] ON[46] ONB[46] ON[45] ONB[45] ON[44] ONB[44]
+ ON[43] ONB[43] ON[42] ONB[42] ON[41] EN[5] ENB[5] ONB[41] ON[40] ONB[40] ON[39]
+ ONB[39] ON[38] ONB[38] ON[37] ONB[37] ON[36] ONB[36] ON[35] ONB[35] ON[34] ONB[34]
+ ON[33] ONB[33] ON[32] ONB[32] EN[0] ENB[0] EN[2] ENB[2] ON[31] ONB[31] ON[30] ONB[30]
+ ON[29] ONB[29] ON[28] ONB[28] ON[27] ONB[27] ON[26] ONB[26] ON[25] EN[3] ENB[3]
+ ONB[25] ON[24] ONB[24] ON[23] ONB[23] ON[22] ONB[22] ON[21] ONB[21] ON[20] ONB[20]
+ ON[19] ONB[19] ON[18] ONB[18] ON[17] ONB[17] ON[16] ONB[16] ON[15] ONB[15] ON[14]
+ ONB[14] ON[13] ONB[13] ON[12] ONB[12] ON[11] ONB[11] ON[10] ONB[10] ON[9] EN[1]
+ ENB[1] ONB[9] ON[8] ONB[8] ON[7] ONB[7] ON[6] ONB[6] ON[5] ONB[5] ON[4] ONB[4] ON[3]
+ ONB[3] ON[2] ONB[2] ON[1] ONB[1] ON[0] ONB[0] VDD VSS VbiasP[0] VbiasP[1] VbiasP[2]
+ VbiasP[3] VbiasP[4] VbiasP[5] VbiasP[6] VbiasP[7] Iout
.ends

* Black-box entry subcircuit for sg13g2_antennanp abstract view
.subckt sg13g2_antennanp VDD VSS A
.ends

.subckt heichips25_pudding VGND VPWR clk ena i_in i_out rst_n ui_in[0] ui_in[1] ui_in[2]
+ ui_in[3] ui_in[4] ui_in[5] ui_in[6] ui_in[7] uio_in[0] uio_in[1] uio_in[2] uio_in[3]
+ uio_in[4] uio_in[5] uio_in[6] uio_in[7] uio_oe[0] uio_oe[1] uio_oe[2] uio_oe[3]
+ uio_oe[4] uio_oe[5] uio_oe[6] uio_oe[7] uio_out[0] uio_out[1] uio_out[2] uio_out[3]
+ uio_out[4] uio_out[5] uio_out[6] uio_out[7] uo_out[0] uo_out[1] uo_out[2] uo_out[3]
+ uo_out[4] uo_out[5] uo_out[6] uo_out[7]
XFILLER_39_266 VPWR VGND sg13g2_decap_8
X_2037_ net228 VGND VPWR _0369_ state\[113\] clknet_leaf_7_clk sg13g2_dfrbpq_1
XFILLER_22_144 VPWR VGND sg13g2_decap_8
XFILLER_7_7 VPWR VGND sg13g2_decap_8
XFILLER_26_96 VPWR VGND sg13g2_decap_8
XFILLER_45_203 VPWR VGND sg13g2_decap_8
XFILLER_10_840 VPWR VGND sg13g2_decap_4
XFILLER_13_177 VPWR VGND sg13g2_decap_8
XFILLER_42_84 VPWR VGND sg13g2_decap_8
XFILLER_6_811 VPWR VGND sg13g2_decap_4
XFILLER_9_137 VPWR VGND sg13g2_decap_8
XFILLER_1_571 VPWR VGND sg13g2_decap_8
XFILLER_5_354 VPWR VGND sg13g2_decap_8
XFILLER_6_866 VPWR VGND sg13g2_decap_8
XFILLER_6_888 VPWR VGND sg13g2_decap_8
XFILLER_36_214 VPWR VGND sg13g2_decap_8
XFILLER_37_737 VPWR VGND sg13g2_decap_8
XFILLER_3_67 VPWR VGND sg13g2_decap_8
XFILLER_49_520 VPWR VGND sg13g2_decap_8
X_1270_ VGND VPWR net85 daisychain\[27\] _0397_ net53 sg13g2_a21oi_1
XFILLER_20_648 VPWR VGND sg13g2_fill_2
XFILLER_44_280 VPWR VGND sg13g2_decap_8
XFILLER_45_770 VPWR VGND sg13g2_decap_8
XFILLER_20_659 VPWR VGND sg13g2_decap_4
X_1606_ VGND VPWR net98 daisychain\[111\] _0649_ net73 sg13g2_a21oi_1
X_0985_ VPWR _0103_ state\[78\] VGND sg13g2_inv_1
XFILLER_9_682 VPWR VGND sg13g2_fill_1
Xfanout105 net108 net105 VPWR VGND sg13g2_buf_1
Xfanout116 net117 net116 VPWR VGND sg13g2_buf_1
Xfanout127 net128 net127 VPWR VGND sg13g2_buf_1
Xfanout138 net145 net138 VPWR VGND sg13g2_buf_1
Xfanout149 net152 net149 VPWR VGND sg13g2_buf_1
X_1537_ _0796_ net128 _0596_ _0597_ VPWR VGND sg13g2_a21o_1
X_1468_ net156 VPWR _0545_ VGND net113 state\[78\] sg13g2_o21ai_1
X_1399_ _0188_ _0492_ _0493_ net38 _0761_ VPWR VGND sg13g2_a22oi_1
XFILLER_35_291 VPWR VGND sg13g2_decap_8
XFILLER_42_217 VPWR VGND sg13g2_decap_8
XFILLER_43_707 VPWR VGND sg13g2_decap_8
XFILLER_10_169 VPWR VGND sg13g2_decap_8
XFILLER_11_615 VPWR VGND sg13g2_fill_1
XFILLER_2_368 VPWR VGND sg13g2_decap_8
XFILLER_3_858 VPWR VGND sg13g2_decap_8
XFILLER_5_4 VPWR VGND sg13g2_decap_8
XFILLER_19_726 VPWR VGND sg13g2_fill_2
XFILLER_37_84 VPWR VGND sg13g2_decap_8
XFILLER_46_567 VPWR VGND sg13g2_decap_8
XFILLER_14_486 VPWR VGND sg13g2_decap_8
XFILLER_18_269 VPWR VGND sg13g2_fill_2
XFILLER_33_228 VPWR VGND sg13g2_decap_8
XFILLER_41_294 VPWR VGND sg13g2_decap_8
XFILLER_5_151 VPWR VGND sg13g2_decap_8
XFILLER_6_641 VPWR VGND sg13g2_decap_8
X_1322_ VGND VPWR net87 daisychain\[40\] _0436_ net49 sg13g2_a21oi_1
X_1253_ _0725_ net118 _0897_ _0384_ VPWR VGND sg13g2_a21o_1
XFILLER_24_206 VPWR VGND sg13g2_decap_8
XFILLER_37_578 VPWR VGND sg13g2_fill_1
XFILLER_49_361 VPWR VGND sg13g2_decap_8
X_1184_ net178 VPWR _0846_ VGND net133 state\[7\] sg13g2_o21ai_1
XFILLER_33_784 VPWR VGND sg13g2_decap_8
X_0968_ VPWR _0085_ state\[61\] VGND sg13g2_inv_1
X_0899_ VPWR _0696_ net147 VGND sg13g2_inv_1
XFILLER_23_20 VPWR VGND sg13g2_decap_8
XFILLER_43_504 VPWR VGND sg13g2_decap_8
XFILLER_23_75 VPWR VGND sg13g2_decap_8
XFILLER_7_427 VPWR VGND sg13g2_decap_8
XFILLER_2_165 VPWR VGND sg13g2_decap_8
XFILLER_3_655 VPWR VGND sg13g2_decap_8
XFILLER_0_35 VPWR VGND sg13g2_decap_8
XFILLER_34_515 VPWR VGND sg13g2_decap_4
XFILLER_34_559 VPWR VGND sg13g2_fill_1
XFILLER_46_364 VPWR VGND sg13g2_decap_8
XFILLER_47_854 VPWR VGND sg13g2_decap_8
XFILLER_14_250 VPWR VGND sg13g2_decap_8
XFILLER_30_710 VPWR VGND sg13g2_fill_1
XFILLER_9_11 VPWR VGND sg13g2_decap_8
X_1940_ net219 VGND VPWR _0272_ state\[16\] clknet_leaf_8_clk sg13g2_dfrbpq_1
X_1871_ net200 VGND VPWR _0203_ daisychain\[75\] clknet_leaf_2_clk sg13g2_dfrbpq_1
XFILLER_9_88 VPWR VGND sg13g2_decap_8
X_1305_ _0738_ net116 _0422_ _0423_ VPWR VGND sg13g2_a21o_1
X_1236_ net174 VPWR _0885_ VGND net130 state\[20\] sg13g2_o21ai_1
XFILLER_40_529 VPWR VGND sg13g2_decap_4
X_1167_ _0130_ _0832_ _0833_ net67 _0703_ VPWR VGND sg13g2_a22oi_1
X_1098_ VPWR _0767_ daisychain\[66\] VGND sg13g2_inv_1
XFILLER_20_264 VPWR VGND sg13g2_fill_2
XFILLER_0_603 VPWR VGND sg13g2_decap_8
XFILLER_18_97 VPWR VGND sg13g2_decap_8
XFILLER_43_301 VPWR VGND sg13g2_decap_8
XFILLER_44_813 VPWR VGND sg13g2_decap_8
XFILLER_11_275 VPWR VGND sg13g2_decap_8
XFILLER_12_732 VPWR VGND sg13g2_fill_1
XFILLER_34_74 VPWR VGND sg13g2_decap_8
XFILLER_43_378 VPWR VGND sg13g2_decap_8
XFILLER_3_452 VPWR VGND sg13g2_decap_8
XFILLER_7_224 VPWR VGND sg13g2_decap_8
XFILLER_19_320 VPWR VGND sg13g2_fill_1
X_2070_ daisychain\[122\] net28 VPWR VGND sg13g2_buf_1
XFILLER_34_389 VPWR VGND sg13g2_decap_4
XFILLER_46_161 VPWR VGND sg13g2_decap_8
XFILLER_47_651 VPWR VGND sg13g2_decap_8
X_1021_ VPWR _0016_ state\[114\] VGND sg13g2_inv_1
XFILLER_30_540 VPWR VGND sg13g2_fill_2
X_1923_ net190 VGND VPWR _0255_ daisychain\[127\] clknet_leaf_0_clk sg13g2_dfrbpq_1
X_1854_ net193 VGND VPWR _0186_ daisychain\[58\] clknet_leaf_14_clk sg13g2_dfrbpq_1
X_1785_ _0663_ VPWR _0373_ VGND net185 _0019_ sg13g2_o21ai_1
XFILLER_29_139 VPWR VGND sg13g2_decap_8
XFILLER_37_161 VPWR VGND sg13g2_decap_8
XFILLER_38_651 VPWR VGND sg13g2_decap_8
X_1219_ _0143_ _0871_ _0872_ net66 _0716_ VPWR VGND sg13g2_a22oi_1
XFILLER_40_315 VPWR VGND sg13g2_decap_8
XFILLER_41_827 VPWR VGND sg13g2_fill_2
XFILLER_20_76 VPWR VGND sg13g2_decap_8
XFILLER_4_249 VPWR VGND sg13g2_decap_8
XFILLER_5_739 VPWR VGND sg13g2_decap_8
XFILLER_0_455 VPWR VGND sg13g2_decap_8
XFILLER_29_41 VPWR VGND sg13g2_decap_8
XFILLER_48_448 VPWR VGND sg13g2_decap_8
XFILLER_49_905 VPWR VGND sg13g2_decap_8
XFILLER_28_161 VPWR VGND sg13g2_decap_8
XFILLER_35_109 VPWR VGND sg13g2_decap_8
XFILLER_43_175 VPWR VGND sg13g2_decap_8
XFILLER_44_665 VPWR VGND sg13g2_decap_8
XFILLER_45_84 VPWR VGND sg13g2_decap_8
XFILLER_12_551 VPWR VGND sg13g2_fill_2
XFILLER_40_871 VPWR VGND sg13g2_decap_8
XFILLER_6_67 VPWR VGND sg13g2_decap_8
X_1570_ VGND VPWR net96 daisychain\[102\] _0622_ net72 sg13g2_a21oi_1
XFILLER_19_183 VPWR VGND sg13g2_decap_8
XFILLER_39_437 VPWR VGND sg13g2_fill_1
X_2053_ ena net11 VPWR VGND sg13g2_buf_1
XFILLER_34_186 VPWR VGND sg13g2_decap_8
X_1004_ VPWR _0124_ state\[97\] VGND sg13g2_inv_1
X_1906_ net226 VGND VPWR _0238_ daisychain\[110\] clknet_leaf_7_clk sg13g2_dfrbpq_1
X_1837_ net204 VGND VPWR _0169_ daisychain\[41\] clknet_leaf_12_clk sg13g2_dfrbpq_1
X_1768_ _0612_ VPWR _0356_ VGND net172 _0001_ sg13g2_o21ai_1
X_1699_ _0405_ VPWR _0287_ VGND net165 _0052_ sg13g2_o21ai_1
XFILLER_14_827 VPWR VGND sg13g2_fill_2
XFILLER_25_153 VPWR VGND sg13g2_decap_8
XFILLER_31_53 VPWR VGND sg13g2_decap_8
XFILLER_40_112 VPWR VGND sg13g2_decap_8
XFILLER_40_189 VPWR VGND sg13g2_decap_8
XFILLER_41_657 VPWR VGND sg13g2_fill_1
XFILLER_9_319 VPWR VGND sg13g2_decap_8
XFILLER_1_753 VPWR VGND sg13g2_decap_8
XFILLER_5_536 VPWR VGND sg13g2_decap_8
Xoutput31 net31 uo_out[5] VPWR VGND sg13g2_buf_1
Xoutput20 net20 uio_out[2] VPWR VGND sg13g2_buf_1
XFILLER_0_252 VPWR VGND sg13g2_decap_8
XFILLER_37_908 VPWR VGND sg13g2_decap_8
XFILLER_48_245 VPWR VGND sg13g2_decap_8
XFILLER_49_746 VPWR VGND sg13g2_decap_4
XFILLER_16_175 VPWR VGND sg13g2_decap_8
XFILLER_17_676 VPWR VGND sg13g2_decap_8
XFILLER_20_819 VPWR VGND sg13g2_fill_1
XFILLER_31_123 VPWR VGND sg13g2_decap_8
XFILLER_44_462 VPWR VGND sg13g2_decap_8
XFILLER_8_396 VPWR VGND sg13g2_decap_8
X_1622_ VGND VPWR net97 daisychain\[115\] _0661_ net74 sg13g2_a21oi_1
XFILLER_9_875 VPWR VGND sg13g2_decap_8
X_1553_ _0800_ net126 _0608_ _0609_ VPWR VGND sg13g2_a21o_1
X_1484_ net170 VPWR _0557_ VGND net125 state\[82\] sg13g2_o21ai_1
XFILLER_39_245 VPWR VGND sg13g2_decap_8
X_2036_ net229 VGND VPWR _0368_ state\[112\] clknet_leaf_7_clk sg13g2_dfrbpq_1
XFILLER_22_123 VPWR VGND sg13g2_decap_8
XFILLER_35_495 VPWR VGND sg13g2_decap_8
XFILLER_46_749 VPWR VGND sg13g2_decap_8
XFILLER_13_156 VPWR VGND sg13g2_decap_8
XFILLER_26_20 VPWR VGND sg13g2_decap_8
XFILLER_26_75 VPWR VGND sg13g2_decap_8
XFILLER_42_911 VPWR VGND sg13g2_decap_8
XFILLER_45_259 VPWR VGND sg13g2_decap_8
XFILLER_9_116 VPWR VGND sg13g2_decap_8
XFILLER_42_63 VPWR VGND sg13g2_decap_8
XFILLER_5_333 VPWR VGND sg13g2_decap_8
XFILLER_1_550 VPWR VGND sg13g2_decap_8
XFILLER_3_46 VPWR VGND sg13g2_decap_8
XFILLER_20_605 VPWR VGND sg13g2_decap_8
X_0984_ VPWR _0102_ state\[77\] VGND sg13g2_inv_1
XFILLER_8_193 VPWR VGND sg13g2_decap_8
X_1605_ _0813_ net144 _0647_ _0648_ VPWR VGND sg13g2_a21o_1
X_1536_ net173 VPWR _0596_ VGND net128 state\[95\] sg13g2_o21ai_1
Xfanout106 net107 net106 VPWR VGND sg13g2_buf_1
Xfanout117 net122 net117 VPWR VGND sg13g2_buf_1
Xfanout128 net129 net128 VPWR VGND sg13g2_buf_1
Xfanout139 net141 net139 VPWR VGND sg13g2_buf_1
X_1467_ _0205_ _0543_ _0544_ net46 _0778_ VPWR VGND sg13g2_a22oi_1
X_1398_ VGND VPWR net81 daisychain\[59\] _0493_ net38 sg13g2_a21oi_1
XFILLER_35_270 VPWR VGND sg13g2_decap_8
XFILLER_36_760 VPWR VGND sg13g2_fill_1
X_2019_ net216 VGND VPWR _0351_ state\[95\] clknet_leaf_4_clk sg13g2_dfrbpq_1
XFILLER_10_148 VPWR VGND sg13g2_decap_8
XFILLER_12_88 VPWR VGND sg13g2_fill_2
XFILLER_2_347 VPWR VGND sg13g2_decap_8
XFILLER_3_837 VPWR VGND sg13g2_decap_8
XFILLER_18_259 VPWR VGND sg13g2_fill_1
XFILLER_19_749 VPWR VGND sg13g2_decap_8
XFILLER_33_207 VPWR VGND sg13g2_decap_8
XFILLER_37_63 VPWR VGND sg13g2_decap_8
XFILLER_46_546 VPWR VGND sg13g2_decap_8
XFILLER_30_925 VPWR VGND sg13g2_fill_2
XFILLER_41_273 VPWR VGND sg13g2_decap_8
XFILLER_42_785 VPWR VGND sg13g2_decap_8
XFILLER_10_671 VPWR VGND sg13g2_fill_1
XFILLER_5_130 VPWR VGND sg13g2_decap_8
XFILLER_6_620 VPWR VGND sg13g2_decap_8
XFILLER_49_340 VPWR VGND sg13g2_decap_8
X_1321_ _0742_ net116 _0434_ _0435_ VPWR VGND sg13g2_a21o_1
X_1252_ net163 VPWR _0897_ VGND net118 state\[24\] sg13g2_o21ai_1
XFILLER_18_760 VPWR VGND sg13g2_fill_1
X_1183_ _0134_ _0844_ _0845_ net67 _0707_ VPWR VGND sg13g2_a22oi_1
XFILLER_32_284 VPWR VGND sg13g2_fill_2
XFILLER_32_295 VPWR VGND sg13g2_fill_2
X_0967_ VPWR _0084_ state\[60\] VGND sg13g2_inv_1
XFILLER_0_807 VPWR VGND sg13g2_decap_8
X_1519_ _0218_ _0582_ _0583_ net58 _0791_ VPWR VGND sg13g2_a22oi_1
X_0898_ VPWR _0695_ daisychain\[123\] VGND sg13g2_inv_1
XFILLER_15_229 VPWR VGND sg13g2_decap_8
XFILLER_23_251 VPWR VGND sg13g2_fill_1
XFILLER_7_406 VPWR VGND sg13g2_decap_8
XFILLER_8_918 VPWR VGND sg13g2_decap_8
XFILLER_3_634 VPWR VGND sg13g2_decap_8
XFILLER_19_502 VPWR VGND sg13g2_fill_1
XFILLER_2_144 VPWR VGND sg13g2_decap_8
XFILLER_47_833 VPWR VGND sg13g2_decap_8
XFILLER_48_84 VPWR VGND sg13g2_decap_8
XFILLER_0_14 VPWR VGND sg13g2_decap_8
XFILLER_15_752 VPWR VGND sg13g2_fill_1
XFILLER_46_343 VPWR VGND sg13g2_decap_8
XFILLER_30_744 VPWR VGND sg13g2_decap_8
X_1870_ net200 VGND VPWR _0202_ daisychain\[74\] clknet_leaf_2_clk sg13g2_dfrbpq_1
XFILLER_9_67 VPWR VGND sg13g2_decap_8
XFILLER_6_494 VPWR VGND sg13g2_decap_8
XFILLER_37_343 VPWR VGND sg13g2_fill_2
XFILLER_38_811 VPWR VGND sg13g2_fill_1
XFILLER_38_888 VPWR VGND sg13g2_decap_8
X_1304_ net159 VPWR _0422_ VGND net116 state\[37\] sg13g2_o21ai_1
X_1235_ _0147_ _0883_ _0884_ net64 _0720_ VPWR VGND sg13g2_a22oi_1
X_1166_ VGND VPWR net94 daisychain\[1\] _0833_ net69 sg13g2_a21oi_1
X_1097_ VPWR _0766_ daisychain\[65\] VGND sg13g2_inv_1
XFILLER_20_243 VPWR VGND sg13g2_fill_2
XFILLER_20_276 VPWR VGND sg13g2_decap_4
X_1999_ net200 VGND VPWR _0331_ state\[75\] clknet_leaf_2_clk sg13g2_dfrbpq_1
XFILLER_0_659 VPWR VGND sg13g2_decap_8
XFILLER_16_538 VPWR VGND sg13g2_fill_2
XFILLER_18_32 VPWR VGND sg13g2_decap_8
XFILLER_18_76 VPWR VGND sg13g2_decap_8
XFILLER_43_357 VPWR VGND sg13g2_decap_8
XFILLER_44_869 VPWR VGND sg13g2_decap_8
XFILLER_11_254 VPWR VGND sg13g2_decap_8
XFILLER_12_766 VPWR VGND sg13g2_fill_1
XFILLER_34_53 VPWR VGND sg13g2_decap_8
XFILLER_7_203 VPWR VGND sg13g2_decap_8
XFILLER_3_431 VPWR VGND sg13g2_decap_8
XFILLER_4_921 VPWR VGND sg13g2_decap_4
XFILLER_46_140 VPWR VGND sg13g2_decap_8
XFILLER_47_630 VPWR VGND sg13g2_decap_8
X_1020_ VPWR _0015_ state\[113\] VGND sg13g2_inv_1
X_1922_ net190 VGND VPWR _0254_ daisychain\[126\] clknet_leaf_0_clk sg13g2_dfrbpq_1
XFILLER_30_552 VPWR VGND sg13g2_fill_2
XFILLER_30_585 VPWR VGND sg13g2_fill_2
X_1853_ net194 VGND VPWR _0185_ daisychain\[57\] clknet_leaf_14_clk sg13g2_dfrbpq_1
X_1784_ _0660_ VPWR _0372_ VGND net185 _0018_ sg13g2_o21ai_1
XFILLER_29_118 VPWR VGND sg13g2_decap_8
XFILLER_41_0 VPWR VGND sg13g2_decap_8
XFILLER_6_291 VPWR VGND sg13g2_decap_8
XFILLER_37_140 VPWR VGND sg13g2_decap_8
XFILLER_38_696 VPWR VGND sg13g2_decap_4
X_1218_ VGND VPWR net92 daisychain\[14\] _0872_ net66 sg13g2_a21oi_1
X_1149_ VPWR _0818_ daisychain\[117\] VGND sg13g2_inv_1
XFILLER_20_22 VPWR VGND sg13g2_fill_1
XFILLER_4_228 VPWR VGND sg13g2_decap_8
XFILLER_5_718 VPWR VGND sg13g2_decap_8
XFILLER_0_434 VPWR VGND sg13g2_decap_8
XFILLER_17_814 VPWR VGND sg13g2_fill_2
XFILLER_28_140 VPWR VGND sg13g2_decap_8
XFILLER_29_20 VPWR VGND sg13g2_decap_8
XFILLER_29_97 VPWR VGND sg13g2_decap_8
XFILLER_48_427 VPWR VGND sg13g2_decap_8
XFILLER_43_154 VPWR VGND sg13g2_decap_8
XFILLER_44_644 VPWR VGND sg13g2_decap_8
XFILLER_45_63 VPWR VGND sg13g2_decap_8
XFILLER_6_46 VPWR VGND sg13g2_decap_8
XFILLER_8_523 VPWR VGND sg13g2_fill_1
XFILLER_4_795 VPWR VGND sg13g2_decap_8
XFILLER_13_4 VPWR VGND sg13g2_fill_1
XFILLER_35_600 VPWR VGND sg13g2_decap_4
X_2052_ ena net10 VPWR VGND sg13g2_buf_1
X_1003_ VPWR _0123_ state\[96\] VGND sg13g2_inv_1
XFILLER_15_390 VPWR VGND sg13g2_fill_2
XFILLER_31_883 VPWR VGND sg13g2_decap_4
XFILLER_34_165 VPWR VGND sg13g2_decap_8
X_1905_ net226 VGND VPWR _0237_ daisychain\[109\] clknet_leaf_7_clk sg13g2_dfrbpq_1
X_1836_ net206 VGND VPWR _0168_ daisychain\[40\] clknet_leaf_13_clk sg13g2_dfrbpq_1
X_1767_ _0609_ VPWR _0355_ VGND net172 _0126_ sg13g2_o21ai_1
X_1698_ _0402_ VPWR _0286_ VGND net166 _0051_ sg13g2_o21ai_1
XFILLER_13_316 VPWR VGND sg13g2_decap_8
XFILLER_13_327 VPWR VGND sg13g2_fill_2
XFILLER_25_132 VPWR VGND sg13g2_decap_8
XFILLER_41_614 VPWR VGND sg13g2_decap_8
XFILLER_31_32 VPWR VGND sg13g2_decap_8
XFILLER_40_168 VPWR VGND sg13g2_decap_8
XFILLER_5_515 VPWR VGND sg13g2_decap_8
XFILLER_0_231 VPWR VGND sg13g2_decap_8
XFILLER_1_732 VPWR VGND sg13g2_decap_8
Xoutput32 net32 uo_out[6] VPWR VGND sg13g2_buf_1
Xoutput21 net21 uio_out[3] VPWR VGND sg13g2_buf_1
Xoutput10 net10 uio_oe[0] VPWR VGND sg13g2_buf_1
XFILLER_44_441 VPWR VGND sg13g2_decap_8
XFILLER_48_224 VPWR VGND sg13g2_decap_8
XFILLER_13_850 VPWR VGND sg13g2_decap_8
XFILLER_16_154 VPWR VGND sg13g2_decap_8
XFILLER_31_102 VPWR VGND sg13g2_decap_8
XFILLER_31_179 VPWR VGND sg13g2_decap_8
XFILLER_32_614 VPWR VGND sg13g2_decap_8
XFILLER_32_625 VPWR VGND sg13g2_fill_1
XFILLER_9_854 VPWR VGND sg13g2_decap_8
XFILLER_8_375 VPWR VGND sg13g2_decap_8
X_1621_ _0817_ net142 _0659_ _0660_ VPWR VGND sg13g2_a21o_1
X_1552_ net171 VPWR _0608_ VGND net126 state\[99\] sg13g2_o21ai_1
XFILLER_39_224 VPWR VGND sg13g2_decap_8
XFILLER_4_592 VPWR VGND sg13g2_decap_8
X_1483_ _0209_ _0555_ _0556_ net58 _0782_ VPWR VGND sg13g2_a22oi_1
XFILLER_22_102 VPWR VGND sg13g2_decap_8
X_2035_ net227 VGND VPWR _0367_ state\[111\] clknet_leaf_7_clk sg13g2_dfrbpq_1
XFILLER_22_179 VPWR VGND sg13g2_decap_8
XFILLER_30_190 VPWR VGND sg13g2_decap_8
XFILLER_2_529 VPWR VGND sg13g2_decap_8
X_1819_ net217 VGND VPWR _0151_ daisychain\[23\] clknet_leaf_11_clk sg13g2_dfrbpq_1
XFILLER_45_238 VPWR VGND sg13g2_decap_8
XFILLER_46_728 VPWR VGND sg13g2_decap_8
XFILLER_13_135 VPWR VGND sg13g2_decap_8
XFILLER_14_614 VPWR VGND sg13g2_decap_4
XFILLER_26_54 VPWR VGND sg13g2_decap_8
XFILLER_41_444 VPWR VGND sg13g2_decap_8
XFILLER_42_42 VPWR VGND sg13g2_decap_8
XFILLER_21_190 VPWR VGND sg13g2_decap_8
XFILLER_5_312 VPWR VGND sg13g2_decap_8
XFILLER_5_389 VPWR VGND sg13g2_decap_8
XFILLER_6_846 VPWR VGND sg13g2_decap_8
XFILLER_3_25 VPWR VGND sg13g2_decap_8
XFILLER_49_555 VPWR VGND sg13g2_decap_8
XFILLER_36_249 VPWR VGND sg13g2_decap_8
XFILLER_8_172 VPWR VGND sg13g2_decap_8
X_0983_ VPWR _0101_ state\[76\] VGND sg13g2_inv_1
XFILLER_9_695 VPWR VGND sg13g2_decap_4
XFILLER_9_662 VPWR VGND sg13g2_decap_8
Xfanout107 net108 net107 VPWR VGND sg13g2_buf_1
Xfanout118 net119 net118 VPWR VGND sg13g2_buf_1
Xfanout129 net145 net129 VPWR VGND sg13g2_buf_1
X_1604_ net187 VPWR _0647_ VGND net144 state\[112\] sg13g2_o21ai_1
X_1535_ _0222_ _0594_ _0595_ net62 _0795_ VPWR VGND sg13g2_a22oi_1
X_1466_ VGND VPWR net82 daisychain\[76\] _0544_ net45 sg13g2_a21oi_1
X_1397_ _0761_ net104 _0491_ _0492_ VPWR VGND sg13g2_a21o_1
X_2018_ net213 VGND VPWR _0350_ state\[94\] clknet_leaf_4_clk sg13g2_dfrbpq_1
XFILLER_10_127 VPWR VGND sg13g2_decap_8
XFILLER_3_816 VPWR VGND sg13g2_decap_8
XFILLER_6_109 VPWR VGND sg13g2_decap_8
XFILLER_2_326 VPWR VGND sg13g2_decap_8
XFILLER_18_216 VPWR VGND sg13g2_decap_8
XFILLER_26_271 VPWR VGND sg13g2_fill_2
XFILLER_37_42 VPWR VGND sg13g2_decap_8
XFILLER_46_525 VPWR VGND sg13g2_decap_8
XFILLER_10_650 VPWR VGND sg13g2_fill_1
XFILLER_30_904 VPWR VGND sg13g2_decap_8
XFILLER_41_252 VPWR VGND sg13g2_decap_8
XFILLER_42_764 VPWR VGND sg13g2_decap_8
XFILLER_45_7 VPWR VGND sg13g2_decap_8
XFILLER_5_186 VPWR VGND sg13g2_decap_8
X_1320_ net159 VPWR _0434_ VGND net116 state\[41\] sg13g2_o21ai_1
XFILLER_1_392 VPWR VGND sg13g2_decap_8
XFILLER_2_893 VPWR VGND sg13g2_decap_8
XFILLER_37_525 VPWR VGND sg13g2_decap_4
X_1251_ _0151_ _0895_ _0896_ net64 _0724_ VPWR VGND sg13g2_a22oi_1
X_1182_ VGND VPWR net93 daisychain\[5\] _0845_ net67 sg13g2_a21oi_1
XFILLER_18_794 VPWR VGND sg13g2_decap_4
XFILLER_20_436 VPWR VGND sg13g2_decap_8
X_0966_ VPWR _0082_ state\[59\] VGND sg13g2_inv_1
XFILLER_9_492 VPWR VGND sg13g2_decap_8
X_1518_ VGND VPWR net90 daisychain\[89\] _0583_ net57 sg13g2_a21oi_1
X_1449_ _0774_ net110 _0530_ _0531_ VPWR VGND sg13g2_a21o_1
XFILLER_15_208 VPWR VGND sg13g2_decap_8
XFILLER_43_539 VPWR VGND sg13g2_decap_8
XFILLER_11_425 VPWR VGND sg13g2_decap_8
XFILLER_12_915 VPWR VGND sg13g2_decap_8
XFILLER_12_926 VPWR VGND sg13g2_fill_1
XFILLER_2_123 VPWR VGND sg13g2_decap_8
XFILLER_3_613 VPWR VGND sg13g2_decap_8
XFILLER_46_322 VPWR VGND sg13g2_decap_8
XFILLER_47_812 VPWR VGND sg13g2_decap_8
XFILLER_48_63 VPWR VGND sg13g2_decap_8
XFILLER_15_764 VPWR VGND sg13g2_decap_8
XFILLER_34_506 VPWR VGND sg13g2_fill_1
XFILLER_46_399 VPWR VGND sg13g2_decap_8
XFILLER_47_889 VPWR VGND sg13g2_decap_8
XFILLER_14_285 VPWR VGND sg13g2_decap_8
XFILLER_9_46 VPWR VGND sg13g2_decap_8
XFILLER_2_690 VPWR VGND sg13g2_decap_8
XFILLER_6_473 VPWR VGND sg13g2_decap_8
X_1303_ _0164_ _0420_ _0421_ net52 _0737_ VPWR VGND sg13g2_a22oi_1
XFILLER_37_322 VPWR VGND sg13g2_decap_4
XFILLER_38_834 VPWR VGND sg13g2_decap_8
XFILLER_49_193 VPWR VGND sg13g2_decap_8
X_1234_ VGND VPWR net92 daisychain\[18\] _0884_ net64 sg13g2_a21oi_1
X_1165_ _0703_ net133 _0831_ _0832_ VPWR VGND sg13g2_a21o_1
X_1096_ VPWR _0765_ daisychain\[64\] VGND sg13g2_inv_1
X_1998_ net200 VGND VPWR _0330_ state\[74\] clknet_leaf_2_clk sg13g2_dfrbpq_1
X_0949_ VPWR _0064_ state\[42\] VGND sg13g2_inv_1
XFILLER_0_638 VPWR VGND sg13g2_decap_8
XFILLER_47_119 VPWR VGND sg13g2_decap_8
XFILLER_48_609 VPWR VGND sg13g2_decap_8
XFILLER_18_55 VPWR VGND sg13g2_decap_8
XFILLER_34_32 VPWR VGND sg13g2_decap_8
XFILLER_43_336 VPWR VGND sg13g2_decap_8
XFILLER_44_848 VPWR VGND sg13g2_decap_8
XFILLER_11_233 VPWR VGND sg13g2_decap_8
XFILLER_12_745 VPWR VGND sg13g2_fill_2
XFILLER_4_900 VPWR VGND sg13g2_decap_8
XFILLER_7_259 VPWR VGND sg13g2_decap_8
XFILLER_1_0 VPWR VGND sg13g2_decap_8
XFILLER_3_410 VPWR VGND sg13g2_decap_8
XFILLER_3_487 VPWR VGND sg13g2_decap_8
XFILLER_15_8 VPWR VGND sg13g2_fill_1
XFILLER_38_119 VPWR VGND sg13g2_decap_8
XFILLER_47_686 VPWR VGND sg13g2_decap_8
XFILLER_34_336 VPWR VGND sg13g2_decap_4
XFILLER_46_196 VPWR VGND sg13g2_decap_8
X_1921_ net190 VGND VPWR _0253_ daisychain\[125\] clknet_leaf_0_clk sg13g2_dfrbpq_1
X_1852_ net193 VGND VPWR _0184_ daisychain\[56\] clknet_leaf_14_clk sg13g2_dfrbpq_1
XFILLER_6_270 VPWR VGND sg13g2_decap_8
X_1783_ _0657_ VPWR _0371_ VGND net185 _0017_ sg13g2_o21ai_1
XFILLER_1_91 VPWR VGND sg13g2_decap_8
XFILLER_37_196 VPWR VGND sg13g2_decap_8
X_1217_ _0716_ net132 _0870_ _0871_ VPWR VGND sg13g2_a21o_1
X_1148_ VPWR _0817_ daisychain\[116\] VGND sg13g2_inv_1
X_1079_ VPWR _0748_ daisychain\[47\] VGND sg13g2_inv_1
XFILLER_33_380 VPWR VGND sg13g2_decap_8
XFILLER_0_413 VPWR VGND sg13g2_decap_8
XFILLER_1_914 VPWR VGND sg13g2_decap_8
XFILLER_1_925 VPWR VGND sg13g2_fill_2
XFILLER_20_34 VPWR VGND sg13g2_fill_1
XFILLER_4_207 VPWR VGND sg13g2_decap_8
XFILLER_29_76 VPWR VGND sg13g2_decap_8
XFILLER_44_623 VPWR VGND sg13g2_decap_8
XFILLER_48_406 VPWR VGND sg13g2_decap_8
XFILLER_12_553 VPWR VGND sg13g2_fill_1
XFILLER_12_564 VPWR VGND sg13g2_decap_8
XFILLER_28_196 VPWR VGND sg13g2_decap_8
XFILLER_40_851 VPWR VGND sg13g2_fill_1
XFILLER_43_133 VPWR VGND sg13g2_decap_8
XFILLER_45_42 VPWR VGND sg13g2_decap_8
XFILLER_6_25 VPWR VGND sg13g2_decap_8
XFILLER_3_284 VPWR VGND sg13g2_decap_8
XFILLER_4_774 VPWR VGND sg13g2_decap_8
XFILLER_34_144 VPWR VGND sg13g2_decap_8
XFILLER_35_645 VPWR VGND sg13g2_decap_8
XFILLER_47_483 VPWR VGND sg13g2_decap_8
X_2051_ net192 VGND VPWR _0383_ state\[127\] clknet_leaf_1_clk sg13g2_dfrbpq_1
X_1002_ VPWR _0122_ state\[95\] VGND sg13g2_inv_1
X_1904_ net226 VGND VPWR _0236_ daisychain\[108\] clknet_leaf_6_clk sg13g2_dfrbpq_1
X_1835_ net206 VGND VPWR _0167_ daisychain\[39\] clknet_leaf_13_clk sg13g2_dfrbpq_1
X_1766_ _0606_ VPWR _0354_ VGND net171 _0125_ sg13g2_o21ai_1
X_1697_ _0399_ VPWR _0285_ VGND net165 _0049_ sg13g2_o21ai_1
XFILLER_15_89 VPWR VGND sg13g2_decap_8
XFILLER_25_111 VPWR VGND sg13g2_decap_8
XFILLER_25_188 VPWR VGND sg13g2_decap_8
XFILLER_40_147 VPWR VGND sg13g2_decap_8
XFILLER_31_11 VPWR VGND sg13g2_decap_8
XFILLER_31_88 VPWR VGND sg13g2_decap_8
XFILLER_0_210 VPWR VGND sg13g2_decap_8
XFILLER_0_287 VPWR VGND sg13g2_decap_8
XFILLER_1_711 VPWR VGND sg13g2_decap_8
XFILLER_1_788 VPWR VGND sg13g2_decap_8
XFILLER_48_203 VPWR VGND sg13g2_decap_8
XFILLER_49_715 VPWR VGND sg13g2_decap_8
Xoutput33 net33 uo_out[7] VPWR VGND sg13g2_buf_1
Xoutput22 net22 uio_out[4] VPWR VGND sg13g2_buf_1
Xoutput11 net11 uio_oe[1] VPWR VGND sg13g2_buf_1
XFILLER_16_133 VPWR VGND sg13g2_decap_8
XFILLER_17_601 VPWR VGND sg13g2_fill_2
XFILLER_17_634 VPWR VGND sg13g2_fill_2
XFILLER_44_420 VPWR VGND sg13g2_decap_8
XFILLER_45_910 VPWR VGND sg13g2_decap_8
XFILLER_12_350 VPWR VGND sg13g2_fill_2
XFILLER_12_361 VPWR VGND sg13g2_decap_8
XFILLER_13_884 VPWR VGND sg13g2_fill_1
XFILLER_31_158 VPWR VGND sg13g2_decap_8
XFILLER_44_497 VPWR VGND sg13g2_decap_8
XFILLER_8_354 VPWR VGND sg13g2_decap_8
XFILLER_9_844 VPWR VGND sg13g2_fill_2
XFILLER_4_571 VPWR VGND sg13g2_decap_8
X_1620_ net186 VPWR _0659_ VGND net142 state\[116\] sg13g2_o21ai_1
X_1551_ _0226_ _0606_ _0607_ net60 _0799_ VPWR VGND sg13g2_a22oi_1
X_1482_ VGND VPWR net90 daisychain\[80\] _0556_ net58 sg13g2_a21oi_1
XFILLER_39_203 VPWR VGND sg13g2_decap_8
XFILLER_22_158 VPWR VGND sg13g2_decap_8
XFILLER_47_280 VPWR VGND sg13g2_decap_8
XFILLER_48_792 VPWR VGND sg13g2_decap_8
X_2034_ net227 VGND VPWR _0366_ state\[110\] clknet_leaf_7_clk sg13g2_dfrbpq_1
XFILLER_10_309 VPWR VGND sg13g2_decap_8
X_1818_ net217 VGND VPWR _0150_ daisychain\[22\] clknet_leaf_11_clk sg13g2_dfrbpq_1
XFILLER_2_508 VPWR VGND sg13g2_decap_8
X_1749_ _0555_ VPWR _0337_ VGND net170 _0107_ sg13g2_o21ai_1
XFILLER_38_280 VPWR VGND sg13g2_decap_8
XFILLER_45_217 VPWR VGND sg13g2_decap_8
XFILLER_46_707 VPWR VGND sg13g2_decap_8
Xdigitalen3.g\[0\].u.inv1 VPWR digitalen3.g\[0\].u.OUTN net9 VGND sg13g2_inv_1
XFILLER_13_114 VPWR VGND sg13g2_decap_8
XFILLER_41_423 VPWR VGND sg13g2_decap_8
XFILLER_42_21 VPWR VGND sg13g2_decap_8
XFILLER_42_98 VPWR VGND sg13g2_decap_8
XFILLER_5_368 VPWR VGND sg13g2_decap_8
XFILLER_6_836 VPWR VGND sg13g2_decap_4
XFILLER_1_585 VPWR VGND sg13g2_decap_8
XFILLER_49_534 VPWR VGND sg13g2_decap_8
XFILLER_17_442 VPWR VGND sg13g2_decap_8
XFILLER_17_475 VPWR VGND sg13g2_fill_1
XFILLER_32_412 VPWR VGND sg13g2_decap_4
XFILLER_36_228 VPWR VGND sg13g2_decap_8
XFILLER_44_294 VPWR VGND sg13g2_decap_8
XFILLER_45_784 VPWR VGND sg13g2_decap_8
XFILLER_8_151 VPWR VGND sg13g2_decap_8
X_0982_ VPWR _0100_ state\[75\] VGND sg13g2_inv_1
Xfanout108 net114 net108 VPWR VGND sg13g2_buf_1
Xfanout119 net121 net119 VPWR VGND sg13g2_buf_1
X_1603_ _0239_ _0645_ _0646_ net73 _0812_ VPWR VGND sg13g2_a22oi_1
X_1534_ VGND VPWR net88 daisychain\[93\] _0595_ net59 sg13g2_a21oi_1
X_1465_ _0778_ net112 _0542_ _0543_ VPWR VGND sg13g2_a21o_1
X_2017_ net213 VGND VPWR _0349_ state\[93\] clknet_leaf_3_clk sg13g2_dfrbpq_1
X_1396_ net148 VPWR _0491_ VGND net104 state\[60\] sg13g2_o21ai_1
XFILLER_10_106 VPWR VGND sg13g2_decap_8
XFILLER_12_13 VPWR VGND sg13g2_decap_8
XFILLER_12_35 VPWR VGND sg13g2_decap_8
XFILLER_2_305 VPWR VGND sg13g2_decap_8
XFILLER_37_21 VPWR VGND sg13g2_decap_8
XFILLER_46_504 VPWR VGND sg13g2_decap_8
XFILLER_26_283 VPWR VGND sg13g2_fill_1
XFILLER_37_98 VPWR VGND sg13g2_decap_8
XFILLER_41_231 VPWR VGND sg13g2_decap_8
XFILLER_42_743 VPWR VGND sg13g2_decap_8
XFILLER_1_371 VPWR VGND sg13g2_decap_8
XFILLER_2_872 VPWR VGND sg13g2_decap_8
XFILLER_38_7 VPWR VGND sg13g2_decap_8
XFILLER_5_165 VPWR VGND sg13g2_decap_8
XFILLER_6_655 VPWR VGND sg13g2_decap_4
XFILLER_6_677 VPWR VGND sg13g2_decap_8
XFILLER_6_688 VPWR VGND sg13g2_fill_1
XFILLER_18_751 VPWR VGND sg13g2_decap_8
XFILLER_49_375 VPWR VGND sg13g2_decap_8
X_1250_ VGND VPWR net92 daisychain\[22\] _0896_ net64 sg13g2_a21oi_1
X_1181_ _0707_ net133 _0843_ _0844_ VPWR VGND sg13g2_a21o_1
XFILLER_45_581 VPWR VGND sg13g2_decap_8
X_0965_ VPWR _0081_ state\[58\] VGND sg13g2_inv_1
X_1517_ _0791_ net124 _0581_ _0582_ VPWR VGND sg13g2_a21o_1
X_1448_ net154 VPWR _0530_ VGND net110 state\[73\] sg13g2_o21ai_1
XFILLER_23_231 VPWR VGND sg13g2_fill_2
XFILLER_43_518 VPWR VGND sg13g2_decap_8
X_1379_ _0183_ _0477_ _0478_ net40 _0756_ VPWR VGND sg13g2_a22oi_1
XFILLER_23_34 VPWR VGND sg13g2_decap_8
XFILLER_23_89 VPWR VGND sg13g2_decap_8
XFILLER_2_102 VPWR VGND sg13g2_decap_8
XFILLER_2_179 VPWR VGND sg13g2_decap_8
XFILLER_3_4 VPWR VGND sg13g2_decap_8
XFILLER_3_669 VPWR VGND sg13g2_decap_8
XFILLER_0_49 VPWR VGND sg13g2_decap_8
XFILLER_46_301 VPWR VGND sg13g2_decap_8
XFILLER_47_868 VPWR VGND sg13g2_decap_8
XFILLER_48_42 VPWR VGND sg13g2_decap_8
XFILLER_14_264 VPWR VGND sg13g2_decap_8
XFILLER_15_743 VPWR VGND sg13g2_decap_8
XFILLER_15_798 VPWR VGND sg13g2_fill_1
XFILLER_30_724 VPWR VGND sg13g2_fill_1
XFILLER_42_595 VPWR VGND sg13g2_decap_8
XFILLER_46_378 VPWR VGND sg13g2_decap_8
XFILLER_9_25 VPWR VGND sg13g2_decap_8
XFILLER_6_452 VPWR VGND sg13g2_decap_8
Xfanout90 net91 net90 VPWR VGND sg13g2_buf_1
XFILLER_36_4 VPWR VGND sg13g2_decap_8
X_1302_ VGND VPWR net85 daisychain\[35\] _0421_ net52 sg13g2_a21oi_1
X_1233_ _0720_ net130 _0882_ _0883_ VPWR VGND sg13g2_a21o_1
XFILLER_18_570 VPWR VGND sg13g2_decap_8
XFILLER_37_301 VPWR VGND sg13g2_decap_8
XFILLER_37_345 VPWR VGND sg13g2_fill_1
XFILLER_49_172 VPWR VGND sg13g2_decap_8
X_1164_ net178 VPWR _0831_ VGND net137 state\[2\] sg13g2_o21ai_1
X_1095_ VPWR _0764_ daisychain\[63\] VGND sg13g2_inv_1
XFILLER_33_573 VPWR VGND sg13g2_fill_1
X_1997_ net199 VGND VPWR _0329_ state\[73\] clknet_leaf_2_clk sg13g2_dfrbpq_1
X_0948_ VPWR _0063_ state\[41\] VGND sg13g2_inv_1
XFILLER_0_617 VPWR VGND sg13g2_decap_8
XFILLER_11_212 VPWR VGND sg13g2_decap_8
XFILLER_34_11 VPWR VGND sg13g2_decap_8
XFILLER_34_88 VPWR VGND sg13g2_decap_8
XFILLER_43_315 VPWR VGND sg13g2_decap_8
XFILLER_44_827 VPWR VGND sg13g2_decap_8
XFILLER_11_289 VPWR VGND sg13g2_decap_8
XFILLER_12_757 VPWR VGND sg13g2_decap_8
XFILLER_7_238 VPWR VGND sg13g2_decap_8
XFILLER_3_466 VPWR VGND sg13g2_decap_8
XFILLER_34_315 VPWR VGND sg13g2_decap_8
XFILLER_46_175 VPWR VGND sg13g2_decap_8
XFILLER_47_665 VPWR VGND sg13g2_decap_8
XFILLER_15_551 VPWR VGND sg13g2_decap_8
XFILLER_15_562 VPWR VGND sg13g2_decap_8
XFILLER_15_573 VPWR VGND sg13g2_fill_2
XFILLER_30_587 VPWR VGND sg13g2_fill_1
XFILLER_42_392 VPWR VGND sg13g2_decap_8
XFILLER_43_882 VPWR VGND sg13g2_decap_8
X_1920_ net190 VGND VPWR _0252_ daisychain\[124\] clknet_leaf_0_clk sg13g2_dfrbpq_1
X_1851_ net194 VGND VPWR _0183_ daisychain\[55\] clknet_leaf_14_clk sg13g2_dfrbpq_1
XFILLER_7_761 VPWR VGND sg13g2_decap_8
X_1782_ _0654_ VPWR _0370_ VGND net185 _0016_ sg13g2_o21ai_1
XFILLER_27_0 VPWR VGND sg13g2_decap_8
X_1216_ net176 VPWR _0870_ VGND net132 state\[15\] sg13g2_o21ai_1
XFILLER_1_70 VPWR VGND sg13g2_decap_8
XFILLER_37_175 VPWR VGND sg13g2_decap_8
XFILLER_40_329 VPWR VGND sg13g2_decap_8
XFILLER_41_808 VPWR VGND sg13g2_decap_8
X_1147_ VPWR _0816_ daisychain\[115\] VGND sg13g2_inv_1
X_1078_ VPWR _0747_ daisychain\[46\] VGND sg13g2_inv_1
XFILLER_0_469 VPWR VGND sg13g2_decap_8
XFILLER_49_919 VPWR VGND sg13g2_decap_8
XFILLER_17_849 VPWR VGND sg13g2_decap_8
XFILLER_28_175 VPWR VGND sg13g2_decap_8
XFILLER_29_55 VPWR VGND sg13g2_decap_8
XFILLER_43_112 VPWR VGND sg13g2_decap_8
XFILLER_44_602 VPWR VGND sg13g2_decap_8
XFILLER_45_21 VPWR VGND sg13g2_decap_8
XFILLER_40_885 VPWR VGND sg13g2_decap_8
XFILLER_43_189 VPWR VGND sg13g2_decap_8
XFILLER_44_679 VPWR VGND sg13g2_decap_8
XFILLER_45_98 VPWR VGND sg13g2_decap_8
XFILLER_8_503 VPWR VGND sg13g2_fill_1
XFILLER_3_263 VPWR VGND sg13g2_decap_8
XFILLER_4_753 VPWR VGND sg13g2_decap_8
X_2050_ net190 VGND VPWR _0382_ state\[126\] clknet_leaf_0_clk sg13g2_dfrbpq_1
XFILLER_19_142 VPWR VGND sg13g2_decap_8
XFILLER_19_197 VPWR VGND sg13g2_decap_8
XFILLER_34_123 VPWR VGND sg13g2_decap_8
XFILLER_47_462 VPWR VGND sg13g2_decap_8
X_1001_ VPWR _0121_ state\[94\] VGND sg13g2_inv_1
XFILLER_15_392 VPWR VGND sg13g2_fill_1
XFILLER_30_340 VPWR VGND sg13g2_decap_8
XFILLER_30_351 VPWR VGND sg13g2_fill_1
XFILLER_30_373 VPWR VGND sg13g2_decap_4
X_1903_ net226 VGND VPWR _0235_ daisychain\[107\] clknet_leaf_6_clk sg13g2_dfrbpq_1
X_1834_ net205 VGND VPWR _0166_ daisychain\[38\] clknet_leaf_13_clk sg13g2_dfrbpq_1
X_1765_ _0603_ VPWR _0353_ VGND net171 _0124_ sg13g2_o21ai_1
X_1696_ _0396_ VPWR _0284_ VGND net164 _0048_ sg13g2_o21ai_1
XFILLER_38_462 VPWR VGND sg13g2_decap_8
XFILLER_15_13 VPWR VGND sg13g2_fill_2
XFILLER_25_167 VPWR VGND sg13g2_decap_8
XFILLER_40_126 VPWR VGND sg13g2_decap_8
XFILLER_31_67 VPWR VGND sg13g2_decap_8
Xoutput23 net23 uio_out[5] VPWR VGND sg13g2_buf_1
Xoutput12 net12 uio_oe[2] VPWR VGND sg13g2_buf_1
XFILLER_0_266 VPWR VGND sg13g2_decap_8
XFILLER_1_767 VPWR VGND sg13g2_decap_8
XFILLER_48_259 VPWR VGND sg13g2_decap_8
XFILLER_16_112 VPWR VGND sg13g2_decap_8
XFILLER_16_189 VPWR VGND sg13g2_decap_8
XFILLER_17_624 VPWR VGND sg13g2_decap_4
XFILLER_32_638 VPWR VGND sg13g2_decap_8
XFILLER_44_476 VPWR VGND sg13g2_decap_8
XFILLER_31_137 VPWR VGND sg13g2_decap_8
XFILLER_40_660 VPWR VGND sg13g2_fill_1
XFILLER_40_693 VPWR VGND sg13g2_decap_4
XFILLER_8_333 VPWR VGND sg13g2_decap_8
XFILLER_4_550 VPWR VGND sg13g2_decap_8
X_1550_ VGND VPWR net88 daisychain\[97\] _0607_ net59 sg13g2_a21oi_1
X_1481_ _0782_ net125 _0554_ _0555_ VPWR VGND sg13g2_a21o_1
XFILLER_35_432 VPWR VGND sg13g2_decap_8
XFILLER_36_911 VPWR VGND sg13g2_decap_8
XFILLER_39_259 VPWR VGND sg13g2_decap_8
XFILLER_48_771 VPWR VGND sg13g2_decap_8
X_2033_ net225 VGND VPWR _0365_ state\[109\] clknet_leaf_7_clk sg13g2_dfrbpq_1
XFILLER_22_137 VPWR VGND sg13g2_decap_8
XFILLER_7_91 VPWR VGND sg13g2_decap_8
X_1817_ net218 VGND VPWR _0149_ daisychain\[21\] clknet_leaf_11_clk sg13g2_dfrbpq_1
X_1748_ _0552_ VPWR _0336_ VGND net156 _0106_ sg13g2_o21ai_1
X_1679_ _0859_ VPWR _0267_ VGND net175 _0022_ sg13g2_o21ai_1
XFILLER_26_34 VPWR VGND sg13g2_fill_2
XFILLER_26_89 VPWR VGND sg13g2_decap_8
XFILLER_42_925 VPWR VGND sg13g2_fill_2
Xdigitalen3.g\[0\].u.inv2 VPWR digitalen3.g\[0\].u.OUTP digitalen3.g\[0\].u.OUTN VGND
+ sg13g2_inv_1
XFILLER_10_822 VPWR VGND sg13g2_decap_8
XFILLER_10_833 VPWR VGND sg13g2_fill_2
XFILLER_10_844 VPWR VGND sg13g2_fill_1
XFILLER_10_855 VPWR VGND sg13g2_decap_4
XFILLER_14_649 VPWR VGND sg13g2_decap_4
XFILLER_42_77 VPWR VGND sg13g2_decap_8
XFILLER_6_804 VPWR VGND sg13g2_decap_8
XFILLER_6_815 VPWR VGND sg13g2_fill_1
XFILLER_5_347 VPWR VGND sg13g2_decap_8
XFILLER_18_922 VPWR VGND sg13g2_decap_4
XFILLER_1_564 VPWR VGND sg13g2_decap_8
XFILLER_36_207 VPWR VGND sg13g2_decap_8
XFILLER_49_513 VPWR VGND sg13g2_decap_8
XFILLER_49_579 VPWR VGND sg13g2_decap_8
XFILLER_33_925 VPWR VGND sg13g2_fill_2
XFILLER_44_273 VPWR VGND sg13g2_decap_8
XFILLER_45_763 VPWR VGND sg13g2_decap_8
X_0981_ VPWR _0099_ state\[74\] VGND sg13g2_inv_1
XFILLER_12_192 VPWR VGND sg13g2_decap_8
XFILLER_8_130 VPWR VGND sg13g2_decap_8
X_1602_ VGND VPWR net98 daisychain\[110\] _0646_ net71 sg13g2_a21oi_1
Xfanout109 net110 net109 VPWR VGND sg13g2_buf_1
X_1533_ _0795_ net128 _0593_ _0594_ VPWR VGND sg13g2_a21o_1
X_1464_ net157 VPWR _0542_ VGND net112 state\[77\] sg13g2_o21ai_1
X_1395_ _0187_ _0489_ _0490_ net38 _0760_ VPWR VGND sg13g2_a22oi_1
XFILLER_36_752 VPWR VGND sg13g2_fill_1
X_2016_ net212 VGND VPWR _0348_ state\[92\] clknet_leaf_4_clk sg13g2_dfrbpq_1
XFILLER_11_608 VPWR VGND sg13g2_decap_8
XFILLER_35_284 VPWR VGND sg13g2_decap_8
XFILLER_14_446 VPWR VGND sg13g2_fill_2
XFILLER_37_77 VPWR VGND sg13g2_decap_8
XFILLER_41_210 VPWR VGND sg13g2_decap_8
XFILLER_42_799 VPWR VGND sg13g2_decap_8
XFILLER_41_287 VPWR VGND sg13g2_decap_8
XFILLER_5_144 VPWR VGND sg13g2_decap_8
XFILLER_6_634 VPWR VGND sg13g2_decap_8
XFILLER_1_350 VPWR VGND sg13g2_decap_8
XFILLER_2_851 VPWR VGND sg13g2_decap_8
XFILLER_17_273 VPWR VGND sg13g2_fill_2
XFILLER_45_560 VPWR VGND sg13g2_decap_8
XFILLER_49_354 VPWR VGND sg13g2_decap_8
X_1180_ net178 VPWR _0843_ VGND net133 state\[6\] sg13g2_o21ai_1
XFILLER_32_221 VPWR VGND sg13g2_decap_8
XFILLER_32_232 VPWR VGND sg13g2_fill_1
XFILLER_33_777 VPWR VGND sg13g2_decap_8
XFILLER_9_450 VPWR VGND sg13g2_fill_1
Xclkbuf_leaf_12_clk clknet_2_0__leaf_clk clknet_leaf_12_clk VPWR VGND sg13g2_buf_8
X_0964_ VPWR _0080_ state\[57\] VGND sg13g2_inv_1
X_1516_ net168 VPWR _0581_ VGND net124 state\[90\] sg13g2_o21ai_1
XFILLER_4_81 VPWR VGND sg13g2_decap_8
X_1447_ _0200_ _0528_ _0529_ net45 _0773_ VPWR VGND sg13g2_a22oi_1
X_1378_ VGND VPWR net80 daisychain\[54\] _0478_ net40 sg13g2_a21oi_1
XFILLER_23_243 VPWR VGND sg13g2_fill_2
XFILLER_23_13 VPWR VGND sg13g2_decap_8
XFILLER_23_68 VPWR VGND sg13g2_decap_8
XFILLER_2_158 VPWR VGND sg13g2_decap_8
XFILLER_3_648 VPWR VGND sg13g2_decap_8
XFILLER_48_21 VPWR VGND sg13g2_decap_8
XFILLER_0_28 VPWR VGND sg13g2_decap_8
XFILLER_15_711 VPWR VGND sg13g2_decap_4
XFILLER_34_519 VPWR VGND sg13g2_fill_1
XFILLER_46_357 VPWR VGND sg13g2_decap_8
XFILLER_47_847 VPWR VGND sg13g2_decap_8
XFILLER_48_98 VPWR VGND sg13g2_decap_8
XFILLER_14_243 VPWR VGND sg13g2_decap_8
XFILLER_30_714 VPWR VGND sg13g2_fill_2
XFILLER_30_758 VPWR VGND sg13g2_fill_2
XFILLER_42_530 VPWR VGND sg13g2_fill_2
Xfanout91 net99 net91 VPWR VGND sg13g2_buf_1
Xfanout80 net81 net80 VPWR VGND sg13g2_buf_1
XFILLER_6_431 VPWR VGND sg13g2_decap_8
XFILLER_29_4 VPWR VGND sg13g2_decap_4
XFILLER_49_151 VPWR VGND sg13g2_decap_8
Xclkbuf_leaf_1_clk clknet_2_1__leaf_clk clknet_leaf_1_clk VPWR VGND sg13g2_buf_8
X_1301_ _0737_ net119 _0419_ _0420_ VPWR VGND sg13g2_a21o_1
X_1232_ net174 VPWR _0882_ VGND net130 state\[19\] sg13g2_o21ai_1
XFILLER_18_560 VPWR VGND sg13g2_fill_1
XFILLER_33_563 VPWR VGND sg13g2_decap_4
X_1163_ _0129_ _0829_ _0830_ net69 _0702_ VPWR VGND sg13g2_a22oi_1
X_1094_ VPWR _0763_ daisychain\[62\] VGND sg13g2_inv_1
XFILLER_9_291 VPWR VGND sg13g2_decap_8
X_1996_ net200 VGND VPWR _0328_ state\[72\] clknet_leaf_2_clk sg13g2_dfrbpq_1
X_0947_ VPWR _0062_ state\[40\] VGND sg13g2_inv_1
XFILLER_44_806 VPWR VGND sg13g2_decap_8
XFILLER_34_67 VPWR VGND sg13g2_decap_8
XFILLER_11_268 VPWR VGND sg13g2_decap_8
XFILLER_3_445 VPWR VGND sg13g2_decap_8
XFILLER_7_217 VPWR VGND sg13g2_decap_8
Xclkload0 clknet_2_1__leaf_clk clkload0/X VPWR VGND sg13g2_buf_8
XFILLER_43_861 VPWR VGND sg13g2_decap_8
XFILLER_46_154 VPWR VGND sg13g2_decap_8
XFILLER_47_644 VPWR VGND sg13g2_decap_8
XFILLER_30_533 VPWR VGND sg13g2_decap_4
XFILLER_42_371 VPWR VGND sg13g2_decap_8
X_1850_ net194 VGND VPWR _0182_ daisychain\[54\] clknet_leaf_15_clk sg13g2_dfrbpq_1
X_1781_ _0651_ VPWR _0369_ VGND net185 _0015_ sg13g2_o21ai_1
XFILLER_37_154 VPWR VGND sg13g2_decap_8
XFILLER_38_644 VPWR VGND sg13g2_decap_8
X_1215_ _0142_ _0868_ _0869_ net70 _0715_ VPWR VGND sg13g2_a22oi_1
X_1146_ VPWR _0815_ daisychain\[114\] VGND sg13g2_inv_1
XFILLER_40_308 VPWR VGND sg13g2_decap_8
X_1077_ VPWR _0746_ daisychain\[45\] VGND sg13g2_inv_1
X_1979_ net196 VGND VPWR _0311_ state\[55\] clknet_leaf_14_clk sg13g2_dfrbpq_1
XFILLER_0_448 VPWR VGND sg13g2_decap_8
XFILLER_20_69 VPWR VGND sg13g2_decap_8
XFILLER_29_34 VPWR VGND sg13g2_decap_8
XFILLER_17_806 VPWR VGND sg13g2_fill_2
XFILLER_28_154 VPWR VGND sg13g2_decap_8
XFILLER_43_168 VPWR VGND sg13g2_decap_8
XFILLER_44_658 VPWR VGND sg13g2_decap_8
XFILLER_45_77 VPWR VGND sg13g2_decap_8
XFILLER_12_544 VPWR VGND sg13g2_decap_4
XFILLER_40_864 VPWR VGND sg13g2_decap_8
XFILLER_3_242 VPWR VGND sg13g2_decap_8
XFILLER_4_732 VPWR VGND sg13g2_decap_8
XFILLER_19_121 VPWR VGND sg13g2_decap_8
XFILLER_39_408 VPWR VGND sg13g2_fill_2
XFILLER_47_441 VPWR VGND sg13g2_decap_8
X_1000_ VPWR _0120_ state\[93\] VGND sg13g2_inv_1
XFILLER_19_176 VPWR VGND sg13g2_decap_8
XFILLER_34_102 VPWR VGND sg13g2_decap_8
XFILLER_34_179 VPWR VGND sg13g2_decap_8
X_1902_ net225 VGND VPWR _0234_ daisychain\[106\] clknet_leaf_6_clk sg13g2_dfrbpq_1
XFILLER_7_592 VPWR VGND sg13g2_decap_8
X_1833_ net205 VGND VPWR _0165_ daisychain\[37\] clknet_leaf_12_clk sg13g2_dfrbpq_1
X_1764_ _0600_ VPWR _0352_ VGND net173 _0123_ sg13g2_o21ai_1
X_1695_ _0393_ VPWR _0283_ VGND net164 _0047_ sg13g2_o21ai_1
XFILLER_25_146 VPWR VGND sg13g2_decap_8
X_1129_ VPWR _0798_ daisychain\[97\] VGND sg13g2_inv_1
XFILLER_40_105 VPWR VGND sg13g2_decap_8
XFILLER_31_46 VPWR VGND sg13g2_decap_8
XFILLER_5_529 VPWR VGND sg13g2_decap_8
Xoutput24 net24 uio_out[6] VPWR VGND sg13g2_buf_1
Xoutput13 net13 uio_oe[3] VPWR VGND sg13g2_buf_1
XFILLER_0_245 VPWR VGND sg13g2_decap_8
XFILLER_1_746 VPWR VGND sg13g2_decap_8
XFILLER_48_238 VPWR VGND sg13g2_decap_8
XFILLER_16_168 VPWR VGND sg13g2_decap_8
XFILLER_17_614 VPWR VGND sg13g2_decap_4
XFILLER_17_636 VPWR VGND sg13g2_fill_1
XFILLER_31_116 VPWR VGND sg13g2_decap_8
XFILLER_44_455 VPWR VGND sg13g2_decap_8
XFILLER_9_802 VPWR VGND sg13g2_fill_2
XFILLER_12_396 VPWR VGND sg13g2_decap_8
XFILLER_8_312 VPWR VGND sg13g2_decap_8
XFILLER_8_389 VPWR VGND sg13g2_decap_8
XFILLER_9_868 VPWR VGND sg13g2_decap_8
XFILLER_9_846 VPWR VGND sg13g2_fill_1
X_1480_ net170 VPWR _0554_ VGND net125 state\[81\] sg13g2_o21ai_1
XFILLER_11_4 VPWR VGND sg13g2_fill_1
XFILLER_39_238 VPWR VGND sg13g2_decap_8
XFILLER_48_750 VPWR VGND sg13g2_decap_8
X_2032_ net225 VGND VPWR _0364_ state\[108\] clknet_leaf_6_clk sg13g2_dfrbpq_1
XFILLER_22_116 VPWR VGND sg13g2_decap_8
XFILLER_7_70 VPWR VGND sg13g2_decap_8
X_1816_ net218 VGND VPWR _0148_ daisychain\[20\] clknet_leaf_11_clk sg13g2_dfrbpq_1
X_1747_ _0549_ VPWR _0335_ VGND net156 _0104_ sg13g2_o21ai_1
X_1678_ _0856_ VPWR _0266_ VGND net177 _0011_ sg13g2_o21ai_1
XFILLER_13_149 VPWR VGND sg13g2_decap_8
XFILLER_26_13 VPWR VGND sg13g2_decap_8
XFILLER_26_68 VPWR VGND sg13g2_decap_8
XFILLER_41_458 VPWR VGND sg13g2_fill_2
XFILLER_42_904 VPWR VGND sg13g2_decap_8
XFILLER_10_801 VPWR VGND sg13g2_decap_8
XFILLER_42_56 VPWR VGND sg13g2_decap_8
XFILLER_5_326 VPWR VGND sg13g2_decap_8
XFILLER_9_109 VPWR VGND sg13g2_decap_8
XFILLER_1_543 VPWR VGND sg13g2_decap_8
XFILLER_3_39 VPWR VGND sg13g2_decap_8
XFILLER_45_742 VPWR VGND sg13g2_decap_8
XFILLER_12_171 VPWR VGND sg13g2_decap_8
XFILLER_13_694 VPWR VGND sg13g2_decap_4
XFILLER_17_488 VPWR VGND sg13g2_fill_1
XFILLER_44_252 VPWR VGND sg13g2_decap_8
X_0980_ VPWR _0098_ state\[73\] VGND sg13g2_inv_1
XFILLER_5_893 VPWR VGND sg13g2_decap_8
XFILLER_8_186 VPWR VGND sg13g2_decap_8
X_1601_ _0812_ net141 _0644_ _0645_ VPWR VGND sg13g2_a21o_1
X_1532_ net173 VPWR _0593_ VGND net125 state\[94\] sg13g2_o21ai_1
XFILLER_9_676 VPWR VGND sg13g2_fill_2
X_1463_ _0204_ _0540_ _0541_ net45 _0777_ VPWR VGND sg13g2_a22oi_1
X_1394_ VGND VPWR net81 daisychain\[58\] _0490_ net38 sg13g2_a21oi_1
XFILLER_35_263 VPWR VGND sg13g2_decap_8
XFILLER_36_731 VPWR VGND sg13g2_decap_8
X_2015_ net212 VGND VPWR _0347_ state\[91\] clknet_leaf_5_clk sg13g2_dfrbpq_1
XFILLER_37_56 VPWR VGND sg13g2_decap_8
XFILLER_46_539 VPWR VGND sg13g2_decap_8
XFILLER_14_403 VPWR VGND sg13g2_decap_4
XFILLER_15_926 VPWR VGND sg13g2_fill_1
XFILLER_30_918 VPWR VGND sg13g2_decap_8
XFILLER_41_266 VPWR VGND sg13g2_decap_8
XFILLER_42_778 VPWR VGND sg13g2_decap_8
XFILLER_10_664 VPWR VGND sg13g2_decap_8
XFILLER_5_123 VPWR VGND sg13g2_decap_8
XFILLER_6_613 VPWR VGND sg13g2_decap_8
XFILLER_2_830 VPWR VGND sg13g2_decap_8
XFILLER_37_506 VPWR VGND sg13g2_decap_4
XFILLER_49_333 VPWR VGND sg13g2_decap_8
XFILLER_17_230 VPWR VGND sg13g2_decap_8
XFILLER_32_200 VPWR VGND sg13g2_decap_8
XFILLER_33_701 VPWR VGND sg13g2_fill_2
X_0963_ VPWR _0079_ state\[56\] VGND sg13g2_inv_1
XFILLER_4_60 VPWR VGND sg13g2_decap_8
XFILLER_5_690 VPWR VGND sg13g2_decap_8
X_1515_ _0217_ _0579_ _0580_ net57 _0790_ VPWR VGND sg13g2_a22oi_1
X_1446_ VGND VPWR net82 daisychain\[71\] _0529_ net45 sg13g2_a21oi_1
X_1377_ _0756_ net106 _0476_ _0477_ VPWR VGND sg13g2_a21o_1
XFILLER_11_439 VPWR VGND sg13g2_fill_1
XFILLER_23_233 VPWR VGND sg13g2_fill_1
XFILLER_36_550 VPWR VGND sg13g2_fill_1
XFILLER_3_627 VPWR VGND sg13g2_decap_8
XFILLER_2_137 VPWR VGND sg13g2_decap_8
XFILLER_14_222 VPWR VGND sg13g2_decap_8
XFILLER_46_336 VPWR VGND sg13g2_decap_8
XFILLER_47_826 VPWR VGND sg13g2_decap_8
XFILLER_48_77 VPWR VGND sg13g2_decap_8
XFILLER_10_461 VPWR VGND sg13g2_decap_8
XFILLER_14_299 VPWR VGND sg13g2_decap_8
XFILLER_15_778 VPWR VGND sg13g2_decap_4
XFILLER_30_737 VPWR VGND sg13g2_decap_8
XFILLER_6_410 VPWR VGND sg13g2_decap_8
Xfanout92 net95 net92 VPWR VGND sg13g2_buf_1
Xfanout81 net84 net81 VPWR VGND sg13g2_buf_1
Xfanout70 net77 net70 VPWR VGND sg13g2_buf_1
XFILLER_10_494 VPWR VGND sg13g2_decap_8
XFILLER_43_7 VPWR VGND sg13g2_decap_8
XFILLER_6_487 VPWR VGND sg13g2_decap_8
XFILLER_49_130 VPWR VGND sg13g2_decap_8
X_1300_ net164 VPWR _0419_ VGND net119 state\[36\] sg13g2_o21ai_1
X_1231_ _0146_ _0880_ _0881_ net70 _0719_ VPWR VGND sg13g2_a22oi_1
X_1162_ VGND VPWR net94 daisychain\[0\] _0830_ net69 sg13g2_a21oi_1
X_1093_ VPWR _0762_ daisychain\[61\] VGND sg13g2_inv_1
XFILLER_20_269 VPWR VGND sg13g2_decap_4
XFILLER_9_270 VPWR VGND sg13g2_decap_8
X_1995_ net202 VGND VPWR _0327_ state\[71\] clknet_leaf_3_clk sg13g2_dfrbpq_1
X_0946_ VPWR _0060_ state\[39\] VGND sg13g2_inv_1
X_1429_ _0769_ net109 _0515_ _0516_ VPWR VGND sg13g2_a21o_1
XFILLER_18_69 VPWR VGND sg13g2_decap_8
XFILLER_11_247 VPWR VGND sg13g2_decap_8
XFILLER_34_46 VPWR VGND sg13g2_decap_8
Xclkload1 clknet_2_2__leaf_clk clkload1/X VPWR VGND sg13g2_buf_8
XFILLER_3_424 VPWR VGND sg13g2_decap_8
XFILLER_4_914 VPWR VGND sg13g2_decap_8
XFILLER_4_925 VPWR VGND sg13g2_fill_2
Xdigitalen2.g\[1\].u.inv1 VPWR digitalen2.g\[1\].u.OUTN net8 VGND sg13g2_inv_1
XFILLER_46_133 VPWR VGND sg13g2_decap_8
XFILLER_47_623 VPWR VGND sg13g2_decap_8
XFILLER_30_512 VPWR VGND sg13g2_fill_1
XFILLER_42_350 VPWR VGND sg13g2_decap_8
XFILLER_43_840 VPWR VGND sg13g2_decap_8
XFILLER_11_770 VPWR VGND sg13g2_fill_2
XFILLER_30_545 VPWR VGND sg13g2_decap_8
XFILLER_30_578 VPWR VGND sg13g2_decap_8
X_1780_ _0648_ VPWR _0368_ VGND net187 _0014_ sg13g2_o21ai_1
XFILLER_6_284 VPWR VGND sg13g2_decap_8
XFILLER_37_133 VPWR VGND sg13g2_decap_8
X_1214_ VGND VPWR net94 daisychain\[13\] _0869_ net70 sg13g2_a21oi_1
X_1145_ VPWR _0814_ daisychain\[113\] VGND sg13g2_inv_1
XFILLER_33_394 VPWR VGND sg13g2_fill_2
X_1076_ VPWR _0745_ daisychain\[44\] VGND sg13g2_inv_1
X_1978_ net195 VGND VPWR _0310_ state\[54\] clknet_leaf_15_clk sg13g2_dfrbpq_1
X_0929_ VPWR _0042_ state\[22\] VGND sg13g2_inv_1
XFILLER_0_427 VPWR VGND sg13g2_decap_8
XFILLER_29_13 VPWR VGND sg13g2_decap_8
XFILLER_12_501 VPWR VGND sg13g2_decap_4
XFILLER_28_133 VPWR VGND sg13g2_decap_8
XFILLER_43_147 VPWR VGND sg13g2_decap_8
XFILLER_44_637 VPWR VGND sg13g2_decap_8
XFILLER_45_56 VPWR VGND sg13g2_decap_8
XFILLER_12_578 VPWR VGND sg13g2_decap_4
XFILLER_6_39 VPWR VGND sg13g2_decap_8
XFILLER_8_516 VPWR VGND sg13g2_decap_8
XFILLER_10_92 VPWR VGND sg13g2_decap_8
XFILLER_3_221 VPWR VGND sg13g2_decap_8
XFILLER_3_298 VPWR VGND sg13g2_decap_8
XFILLER_4_711 VPWR VGND sg13g2_decap_8
XFILLER_4_788 VPWR VGND sg13g2_decap_8
XFILLER_19_100 VPWR VGND sg13g2_decap_8
XFILLER_47_420 VPWR VGND sg13g2_decap_8
XFILLER_47_497 VPWR VGND sg13g2_decap_8
XFILLER_15_372 VPWR VGND sg13g2_fill_1
XFILLER_15_383 VPWR VGND sg13g2_decap_8
XFILLER_31_876 VPWR VGND sg13g2_decap_8
XFILLER_34_158 VPWR VGND sg13g2_decap_8
XFILLER_35_659 VPWR VGND sg13g2_fill_2
X_1901_ net225 VGND VPWR _0233_ daisychain\[105\] clknet_leaf_6_clk sg13g2_dfrbpq_1
X_1832_ net207 VGND VPWR _0164_ daisychain\[36\] clknet_leaf_12_clk sg13g2_dfrbpq_1
XFILLER_7_560 VPWR VGND sg13g2_decap_8
X_1763_ _0597_ VPWR _0351_ VGND net173 _0122_ sg13g2_o21ai_1
X_1694_ _0390_ VPWR _0282_ VGND net163 _0046_ sg13g2_o21ai_1
XFILLER_13_309 VPWR VGND sg13g2_decap_8
XFILLER_15_48 VPWR VGND sg13g2_decap_4
XFILLER_25_125 VPWR VGND sg13g2_decap_8
XFILLER_38_497 VPWR VGND sg13g2_decap_8
XFILLER_41_607 VPWR VGND sg13g2_decap_8
X_1128_ VPWR _0797_ daisychain\[96\] VGND sg13g2_inv_1
X_1059_ VPWR _0728_ daisychain\[27\] VGND sg13g2_inv_1
XFILLER_31_25 VPWR VGND sg13g2_decap_8
XFILLER_5_508 VPWR VGND sg13g2_decap_8
XFILLER_0_224 VPWR VGND sg13g2_decap_8
XFILLER_1_725 VPWR VGND sg13g2_decap_8
Xoutput25 net25 uio_out[7] VPWR VGND sg13g2_buf_1
Xoutput14 net14 uio_oe[4] VPWR VGND sg13g2_buf_1
XFILLER_45_924 VPWR VGND sg13g2_fill_2
XFILLER_48_217 VPWR VGND sg13g2_decap_8
XFILLER_49_729 VPWR VGND sg13g2_decap_4
XFILLER_13_843 VPWR VGND sg13g2_decap_8
XFILLER_16_147 VPWR VGND sg13g2_decap_8
XFILLER_32_607 VPWR VGND sg13g2_decap_8
XFILLER_44_434 VPWR VGND sg13g2_decap_8
XFILLER_12_375 VPWR VGND sg13g2_fill_1
XFILLER_12_386 VPWR VGND sg13g2_decap_4
XFILLER_8_368 VPWR VGND sg13g2_decap_8
XFILLER_39_217 VPWR VGND sg13g2_decap_8
XFILLER_4_585 VPWR VGND sg13g2_decap_8
XFILLER_47_294 VPWR VGND sg13g2_decap_8
X_2031_ net226 VGND VPWR _0363_ state\[107\] clknet_leaf_6_clk sg13g2_dfrbpq_1
XFILLER_15_180 VPWR VGND sg13g2_decap_8
XFILLER_30_183 VPWR VGND sg13g2_decap_8
XFILLER_31_662 VPWR VGND sg13g2_decap_8
X_1815_ net217 VGND VPWR _0147_ daisychain\[19\] clknet_leaf_11_clk sg13g2_dfrbpq_1
XFILLER_8_891 VPWR VGND sg13g2_fill_1
X_1746_ _0546_ VPWR _0334_ VGND net156 _0103_ sg13g2_o21ai_1
X_1677_ _0853_ VPWR _0265_ VGND net177 _0127_ sg13g2_o21ai_1
XFILLER_13_128 VPWR VGND sg13g2_decap_8
XFILLER_14_607 VPWR VGND sg13g2_decap_8
XFILLER_14_618 VPWR VGND sg13g2_fill_1
XFILLER_26_47 VPWR VGND sg13g2_decap_8
XFILLER_38_294 VPWR VGND sg13g2_decap_8
XFILLER_41_437 VPWR VGND sg13g2_decap_8
XFILLER_42_35 VPWR VGND sg13g2_decap_8
XFILLER_21_183 VPWR VGND sg13g2_decap_8
XFILLER_5_305 VPWR VGND sg13g2_decap_8
XFILLER_6_828 VPWR VGND sg13g2_fill_2
XFILLER_1_522 VPWR VGND sg13g2_decap_8
XFILLER_1_599 VPWR VGND sg13g2_decap_8
XFILLER_3_18 VPWR VGND sg13g2_decap_8
XFILLER_49_548 VPWR VGND sg13g2_decap_8
XFILLER_17_423 VPWR VGND sg13g2_fill_2
XFILLER_17_456 VPWR VGND sg13g2_fill_2
XFILLER_44_231 VPWR VGND sg13g2_decap_8
XFILLER_45_721 VPWR VGND sg13g2_decap_8
XFILLER_45_798 VPWR VGND sg13g2_decap_8
XFILLER_12_150 VPWR VGND sg13g2_decap_8
XFILLER_16_91 VPWR VGND sg13g2_decap_8
XFILLER_9_655 VPWR VGND sg13g2_decap_8
XFILLER_4_382 VPWR VGND sg13g2_decap_8
XFILLER_5_872 VPWR VGND sg13g2_decap_8
XFILLER_8_165 VPWR VGND sg13g2_decap_8
X_1600_ net184 VPWR _0644_ VGND net141 state\[111\] sg13g2_o21ai_1
X_1531_ _0221_ _0591_ _0592_ net59 _0794_ VPWR VGND sg13g2_a22oi_1
X_1462_ VGND VPWR net82 daisychain\[75\] _0541_ net45 sg13g2_a21oi_1
XFILLER_36_710 VPWR VGND sg13g2_decap_4
XFILLER_48_581 VPWR VGND sg13g2_decap_8
X_1393_ _0760_ net104 _0488_ _0489_ VPWR VGND sg13g2_a21o_1
XFILLER_35_242 VPWR VGND sg13g2_decap_8
X_2014_ net212 VGND VPWR _0346_ state\[90\] clknet_leaf_5_clk sg13g2_dfrbpq_1
XFILLER_12_27 VPWR VGND sg13g2_fill_2
XFILLER_3_809 VPWR VGND sg13g2_decap_8
XFILLER_2_319 VPWR VGND sg13g2_decap_8
X_1729_ _0495_ VPWR _0317_ VGND net148 _0085_ sg13g2_o21ai_1
XFILLER_18_209 VPWR VGND sg13g2_decap_8
XFILLER_37_35 VPWR VGND sg13g2_decap_8
XFILLER_39_570 VPWR VGND sg13g2_decap_8
XFILLER_42_702 VPWR VGND sg13g2_decap_4
XFILLER_42_713 VPWR VGND sg13g2_fill_2
XFILLER_46_518 VPWR VGND sg13g2_decap_8
XFILLER_41_245 VPWR VGND sg13g2_decap_8
XFILLER_42_757 VPWR VGND sg13g2_decap_8
XFILLER_5_102 VPWR VGND sg13g2_decap_8
XFILLER_5_179 VPWR VGND sg13g2_decap_8
XFILLER_1_385 VPWR VGND sg13g2_decap_8
XFILLER_2_886 VPWR VGND sg13g2_decap_8
XFILLER_49_312 VPWR VGND sg13g2_decap_8
XFILLER_49_389 VPWR VGND sg13g2_decap_4
XFILLER_18_787 VPWR VGND sg13g2_decap_8
XFILLER_45_595 VPWR VGND sg13g2_decap_8
XFILLER_20_429 VPWR VGND sg13g2_decap_8
X_0962_ VPWR _0078_ state\[55\] VGND sg13g2_inv_1
XFILLER_9_485 VPWR VGND sg13g2_fill_2
X_1514_ VGND VPWR net90 daisychain\[88\] _0580_ net57 sg13g2_a21oi_1
X_1445_ _0773_ net111 _0527_ _0528_ VPWR VGND sg13g2_a21o_1
X_1376_ net151 VPWR _0476_ VGND net108 state\[55\] sg13g2_o21ai_1
XFILLER_11_418 VPWR VGND sg13g2_decap_8
XFILLER_12_908 VPWR VGND sg13g2_decap_8
XFILLER_23_201 VPWR VGND sg13g2_fill_1
XFILLER_23_48 VPWR VGND sg13g2_decap_8
XFILLER_2_116 VPWR VGND sg13g2_decap_8
XFILLER_3_606 VPWR VGND sg13g2_decap_8
XFILLER_46_315 VPWR VGND sg13g2_decap_8
XFILLER_47_805 VPWR VGND sg13g2_decap_8
XFILLER_48_56 VPWR VGND sg13g2_decap_8
XFILLER_14_201 VPWR VGND sg13g2_decap_8
XFILLER_15_702 VPWR VGND sg13g2_fill_2
XFILLER_15_757 VPWR VGND sg13g2_decap_8
XFILLER_10_440 VPWR VGND sg13g2_decap_8
XFILLER_14_278 VPWR VGND sg13g2_decap_8
XFILLER_30_716 VPWR VGND sg13g2_fill_1
XFILLER_7_923 VPWR VGND sg13g2_decap_4
XFILLER_9_39 VPWR VGND sg13g2_decap_8
Xfanout93 net94 net93 VPWR VGND sg13g2_buf_1
Xfanout82 net83 net82 VPWR VGND sg13g2_buf_1
Xfanout71 net73 net71 VPWR VGND sg13g2_buf_1
Xfanout60 net61 net60 VPWR VGND sg13g2_buf_1
XFILLER_2_683 VPWR VGND sg13g2_decap_8
XFILLER_6_466 VPWR VGND sg13g2_decap_8
XFILLER_18_551 VPWR VGND sg13g2_decap_8
XFILLER_1_182 VPWR VGND sg13g2_decap_8
XFILLER_37_315 VPWR VGND sg13g2_decap_8
XFILLER_38_827 VPWR VGND sg13g2_decap_8
XFILLER_49_186 VPWR VGND sg13g2_decap_8
X_1230_ VGND VPWR net95 daisychain\[17\] _0881_ net70 sg13g2_a21oi_1
X_1161_ _0702_ net136 _0828_ _0829_ VPWR VGND sg13g2_a21o_1
X_1092_ VPWR _0761_ daisychain\[60\] VGND sg13g2_inv_1
XFILLER_20_248 VPWR VGND sg13g2_decap_4
XFILLER_33_521 VPWR VGND sg13g2_decap_4
XFILLER_33_532 VPWR VGND sg13g2_fill_1
XFILLER_45_392 VPWR VGND sg13g2_decap_8
XFILLER_46_882 VPWR VGND sg13g2_decap_8
X_1994_ net199 VGND VPWR _0326_ state\[70\] clknet_leaf_3_clk sg13g2_dfrbpq_1
X_0945_ VPWR _0059_ state\[38\] VGND sg13g2_inv_1
X_1428_ net153 VPWR _0515_ VGND net109 state\[68\] sg13g2_o21ai_1
XFILLER_34_25 VPWR VGND sg13g2_decap_8
XFILLER_43_329 VPWR VGND sg13g2_decap_8
X_1359_ _0178_ _0462_ _0463_ net41 _0751_ VPWR VGND sg13g2_a22oi_1
XFILLER_11_226 VPWR VGND sg13g2_decap_8
Xclkload2 clknet_2_3__leaf_clk clkload2/X VPWR VGND sg13g2_buf_8
XFILLER_3_403 VPWR VGND sg13g2_decap_8
Xdigitalen2.g\[1\].u.inv2 VPWR digitalen2.g\[1\].u.OUTP digitalen2.g\[1\].u.OUTN VGND
+ sg13g2_inv_1
XFILLER_46_112 VPWR VGND sg13g2_decap_8
XFILLER_47_602 VPWR VGND sg13g2_decap_8
XFILLER_47_679 VPWR VGND sg13g2_decap_8
XFILLER_34_329 VPWR VGND sg13g2_decap_8
XFILLER_43_896 VPWR VGND sg13g2_decap_8
XFILLER_46_189 VPWR VGND sg13g2_decap_8
XFILLER_10_281 VPWR VGND sg13g2_decap_8
XFILLER_24_80 VPWR VGND sg13g2_decap_8
XFILLER_6_263 VPWR VGND sg13g2_decap_8
XFILLER_2_480 VPWR VGND sg13g2_decap_8
XFILLER_34_4 VPWR VGND sg13g2_decap_8
X_1213_ _0715_ net136 _0867_ _0868_ VPWR VGND sg13g2_a21o_1
XFILLER_18_392 VPWR VGND sg13g2_fill_1
XFILLER_1_84 VPWR VGND sg13g2_decap_8
XFILLER_37_112 VPWR VGND sg13g2_decap_8
XFILLER_37_189 VPWR VGND sg13g2_decap_8
X_1144_ VPWR _0813_ daisychain\[112\] VGND sg13g2_inv_1
X_1075_ VPWR _0744_ daisychain\[43\] VGND sg13g2_inv_1
XFILLER_33_373 VPWR VGND sg13g2_decap_8
X_1977_ net195 VGND VPWR _0309_ state\[53\] clknet_leaf_15_clk sg13g2_dfrbpq_1
XFILLER_1_907 VPWR VGND sg13g2_decap_8
XFILLER_20_27 VPWR VGND sg13g2_decap_8
X_0928_ VPWR _0041_ state\[21\] VGND sg13g2_inv_1
XFILLER_17_808 VPWR VGND sg13g2_fill_1
XFILLER_28_112 VPWR VGND sg13g2_decap_8
XFILLER_29_69 VPWR VGND sg13g2_decap_8
XFILLER_28_189 VPWR VGND sg13g2_decap_8
XFILLER_40_811 VPWR VGND sg13g2_decap_4
XFILLER_43_126 VPWR VGND sg13g2_decap_8
XFILLER_44_616 VPWR VGND sg13g2_decap_8
XFILLER_45_35 VPWR VGND sg13g2_decap_8
Xdigitalen3.g\[3\].u.inv1 VPWR digitalen3.g\[3\].u.OUTN net9 VGND sg13g2_inv_1
XFILLER_12_557 VPWR VGND sg13g2_decap_8
XFILLER_3_200 VPWR VGND sg13g2_decap_8
XFILLER_40_899 VPWR VGND sg13g2_decap_8
XFILLER_6_18 VPWR VGND sg13g2_decap_8
XFILLER_10_71 VPWR VGND sg13g2_decap_8
XFILLER_3_277 VPWR VGND sg13g2_decap_8
XFILLER_48_911 VPWR VGND sg13g2_decap_8
XFILLER_4_767 VPWR VGND sg13g2_decap_8
XFILLER_19_156 VPWR VGND sg13g2_fill_2
XFILLER_34_137 VPWR VGND sg13g2_decap_8
XFILLER_47_476 VPWR VGND sg13g2_decap_8
XFILLER_43_693 VPWR VGND sg13g2_fill_2
X_1900_ net225 VGND VPWR _0232_ daisychain\[104\] clknet_leaf_6_clk sg13g2_dfrbpq_1
X_1831_ net207 VGND VPWR _0163_ daisychain\[35\] clknet_leaf_12_clk sg13g2_dfrbpq_1
X_1762_ _0594_ VPWR _0350_ VGND net170 _0121_ sg13g2_o21ai_1
X_1693_ _0387_ VPWR _0281_ VGND net163 _0045_ sg13g2_o21ai_1
XFILLER_38_443 VPWR VGND sg13g2_decap_4
XFILLER_25_104 VPWR VGND sg13g2_decap_8
XFILLER_38_476 VPWR VGND sg13g2_decap_4
X_1127_ VPWR _0796_ daisychain\[95\] VGND sg13g2_inv_1
X_1058_ VPWR _0727_ daisychain\[26\] VGND sg13g2_inv_1
XFILLER_0_203 VPWR VGND sg13g2_decap_8
XFILLER_1_704 VPWR VGND sg13g2_decap_8
XFILLER_49_708 VPWR VGND sg13g2_decap_8
Xoutput26 net26 uo_out[0] VPWR VGND sg13g2_buf_1
Xoutput15 net15 uio_oe[5] VPWR VGND sg13g2_buf_1
XFILLER_16_126 VPWR VGND sg13g2_decap_8
XFILLER_44_413 VPWR VGND sg13g2_decap_8
XFILLER_45_903 VPWR VGND sg13g2_decap_8
XFILLER_12_332 VPWR VGND sg13g2_decap_8
XFILLER_24_192 VPWR VGND sg13g2_decap_8
XFILLER_9_804 VPWR VGND sg13g2_fill_1
XFILLER_21_92 VPWR VGND sg13g2_decap_8
XFILLER_4_564 VPWR VGND sg13g2_decap_8
XFILLER_8_347 VPWR VGND sg13g2_decap_8
X_2030_ net225 VGND VPWR _0362_ state\[106\] clknet_leaf_6_clk sg13g2_dfrbpq_1
Xdigitalen0.g\[0\].u.inv1 VPWR digitalen0.g\[0\].u.OUTN net6 VGND sg13g2_inv_1
XFILLER_36_925 VPWR VGND sg13g2_fill_2
XFILLER_47_273 VPWR VGND sg13g2_decap_8
XFILLER_48_785 VPWR VGND sg13g2_decap_8
XFILLER_30_162 VPWR VGND sg13g2_decap_8
XFILLER_43_490 VPWR VGND sg13g2_decap_8
XFILLER_8_870 VPWR VGND sg13g2_fill_2
X_1814_ net217 VGND VPWR _0146_ daisychain\[18\] clknet_leaf_9_clk sg13g2_dfrbpq_1
X_1745_ _0543_ VPWR _0333_ VGND net155 _0102_ sg13g2_o21ai_1
X_1676_ _0850_ VPWR _0264_ VGND net177 _0116_ sg13g2_o21ai_1
XFILLER_38_273 VPWR VGND sg13g2_decap_8
XFILLER_21_162 VPWR VGND sg13g2_decap_8
XFILLER_41_416 VPWR VGND sg13g2_decap_8
XFILLER_42_14 VPWR VGND sg13g2_decap_8
XFILLER_1_501 VPWR VGND sg13g2_decap_8
XFILLER_1_578 VPWR VGND sg13g2_decap_8
XFILLER_49_527 VPWR VGND sg13g2_decap_8
XFILLER_16_70 VPWR VGND sg13g2_decap_8
XFILLER_17_435 VPWR VGND sg13g2_decap_8
XFILLER_32_405 VPWR VGND sg13g2_decap_8
XFILLER_44_210 VPWR VGND sg13g2_decap_8
XFILLER_44_287 VPWR VGND sg13g2_decap_8
XFILLER_45_700 VPWR VGND sg13g2_decap_8
XFILLER_45_777 VPWR VGND sg13g2_decap_8
XFILLER_40_471 VPWR VGND sg13g2_fill_2
XFILLER_8_144 VPWR VGND sg13g2_decap_8
XFILLER_9_678 VPWR VGND sg13g2_fill_1
XFILLER_9_645 VPWR VGND sg13g2_fill_2
XFILLER_4_361 VPWR VGND sg13g2_decap_8
XFILLER_5_851 VPWR VGND sg13g2_decap_8
X_1530_ VGND VPWR net88 daisychain\[92\] _0592_ net59 sg13g2_a21oi_1
X_1461_ _0777_ net111 _0539_ _0540_ VPWR VGND sg13g2_a21o_1
X_1392_ net148 VPWR _0488_ VGND net104 state\[59\] sg13g2_o21ai_1
XFILLER_35_221 VPWR VGND sg13g2_decap_8
XFILLER_36_722 VPWR VGND sg13g2_decap_4
XFILLER_48_560 VPWR VGND sg13g2_decap_8
X_2013_ net212 VGND VPWR _0345_ state\[89\] clknet_leaf_4_clk sg13g2_dfrbpq_1
XFILLER_31_460 VPWR VGND sg13g2_fill_2
XFILLER_31_471 VPWR VGND sg13g2_decap_8
XFILLER_35_298 VPWR VGND sg13g2_decap_8
Xclkbuf_leaf_15_clk clknet_2_0__leaf_clk clknet_leaf_15_clk VPWR VGND sg13g2_buf_8
X_1728_ _0492_ VPWR _0316_ VGND net148 _0084_ sg13g2_o21ai_1
XFILLER_37_14 VPWR VGND sg13g2_decap_8
X_1659_ _0253_ _0687_ _0688_ net34 _0697_ VPWR VGND sg13g2_a22oi_1
XFILLER_26_265 VPWR VGND sg13g2_fill_1
XFILLER_26_276 VPWR VGND sg13g2_decap_8
XFILLER_41_224 VPWR VGND sg13g2_decap_8
XFILLER_10_699 VPWR VGND sg13g2_decap_4
XFILLER_2_865 VPWR VGND sg13g2_decap_8
XFILLER_5_158 VPWR VGND sg13g2_decap_8
XFILLER_6_648 VPWR VGND sg13g2_decap_8
XFILLER_6_659 VPWR VGND sg13g2_fill_2
XFILLER_18_722 VPWR VGND sg13g2_fill_1
XFILLER_1_364 VPWR VGND sg13g2_decap_8
XFILLER_37_519 VPWR VGND sg13g2_fill_2
XFILLER_49_368 VPWR VGND sg13g2_decap_8
XFILLER_18_766 VPWR VGND sg13g2_decap_8
XFILLER_33_725 VPWR VGND sg13g2_fill_1
XFILLER_33_758 VPWR VGND sg13g2_fill_1
XFILLER_45_574 VPWR VGND sg13g2_decap_8
X_0961_ VPWR _0077_ state\[54\] VGND sg13g2_inv_1
XFILLER_13_471 VPWR VGND sg13g2_fill_1
XFILLER_41_780 VPWR VGND sg13g2_decap_8
XFILLER_4_95 VPWR VGND sg13g2_decap_8
Xclkbuf_leaf_4_clk clknet_2_3__leaf_clk clknet_leaf_4_clk VPWR VGND sg13g2_buf_8
X_1513_ _0790_ net129 _0578_ _0579_ VPWR VGND sg13g2_a21o_1
X_1444_ net155 VPWR _0527_ VGND net111 state\[72\] sg13g2_o21ai_1
X_1375_ _0182_ _0474_ _0475_ net40 _0755_ VPWR VGND sg13g2_a22oi_1
XFILLER_36_530 VPWR VGND sg13g2_fill_2
XFILLER_49_891 VPWR VGND sg13g2_decap_8
XFILLER_20_920 VPWR VGND sg13g2_decap_8
XFILLER_23_27 VPWR VGND sg13g2_decap_8
XFILLER_48_35 VPWR VGND sg13g2_decap_8
XFILLER_14_257 VPWR VGND sg13g2_decap_8
XFILLER_30_728 VPWR VGND sg13g2_fill_1
XFILLER_42_566 VPWR VGND sg13g2_fill_2
XFILLER_9_18 VPWR VGND sg13g2_decap_8
XFILLER_10_474 VPWR VGND sg13g2_decap_4
XFILLER_6_445 VPWR VGND sg13g2_decap_8
Xfanout94 net95 net94 VPWR VGND sg13g2_buf_1
Xfanout83 net84 net83 VPWR VGND sg13g2_buf_1
Xfanout72 net73 net72 VPWR VGND sg13g2_buf_1
Xfanout61 net62 net61 VPWR VGND sg13g2_buf_1
Xfanout50 net51 net50 VPWR VGND sg13g2_buf_1
XFILLER_1_161 VPWR VGND sg13g2_decap_8
XFILLER_2_662 VPWR VGND sg13g2_decap_8
XFILLER_45_371 VPWR VGND sg13g2_decap_8
XFILLER_46_861 VPWR VGND sg13g2_decap_8
XFILLER_49_165 VPWR VGND sg13g2_decap_8
X_1160_ net180 VPWR _0828_ VGND net136 state\[1\] sg13g2_o21ai_1
X_1091_ VPWR _0760_ daisychain\[59\] VGND sg13g2_inv_1
X_1993_ net199 VGND VPWR _0325_ state\[69\] clknet_leaf_3_clk sg13g2_dfrbpq_1
X_0944_ VPWR _0058_ state\[37\] VGND sg13g2_inv_1
X_1427_ _0195_ _0513_ _0514_ net43 _0768_ VPWR VGND sg13g2_a22oi_1
X_1358_ VGND VPWR net80 daisychain\[49\] _0463_ net41 sg13g2_a21oi_1
XFILLER_11_205 VPWR VGND sg13g2_decap_8
XFILLER_12_728 VPWR VGND sg13g2_decap_4
XFILLER_36_382 VPWR VGND sg13g2_decap_8
XFILLER_43_308 VPWR VGND sg13g2_decap_8
X_1289_ _0734_ net119 _0410_ _0411_ VPWR VGND sg13g2_a21o_1
XFILLER_20_794 VPWR VGND sg13g2_fill_1
Xclkload3 clkload3/Y clknet_leaf_12_clk VPWR VGND sg13g2_inv_2
XFILLER_3_459 VPWR VGND sg13g2_decap_8
XFILLER_46_168 VPWR VGND sg13g2_decap_8
XFILLER_47_658 VPWR VGND sg13g2_decap_8
XFILLER_42_385 VPWR VGND sg13g2_decap_8
XFILLER_43_875 VPWR VGND sg13g2_decap_8
XFILLER_10_260 VPWR VGND sg13g2_decap_8
XFILLER_11_772 VPWR VGND sg13g2_fill_1
XFILLER_40_91 VPWR VGND sg13g2_decap_8
XFILLER_6_242 VPWR VGND sg13g2_decap_8
XFILLER_7_754 VPWR VGND sg13g2_decap_8
X_1212_ net180 VPWR _0867_ VGND net136 state\[14\] sg13g2_o21ai_1
XFILLER_18_371 VPWR VGND sg13g2_decap_8
XFILLER_1_63 VPWR VGND sg13g2_decap_8
XFILLER_33_341 VPWR VGND sg13g2_fill_2
XFILLER_37_168 VPWR VGND sg13g2_decap_8
XFILLER_38_658 VPWR VGND sg13g2_decap_4
X_1143_ VPWR _0812_ daisychain\[111\] VGND sg13g2_inv_1
X_1074_ VPWR _0743_ daisychain\[42\] VGND sg13g2_inv_1
XFILLER_33_396 VPWR VGND sg13g2_fill_1
X_1976_ net195 VGND VPWR _0308_ state\[52\] clknet_leaf_15_clk sg13g2_dfrbpq_1
X_0927_ VPWR _0040_ state\[20\] VGND sg13g2_inv_1
XFILLER_28_168 VPWR VGND sg13g2_decap_8
XFILLER_29_48 VPWR VGND sg13g2_decap_8
XFILLER_43_105 VPWR VGND sg13g2_decap_8
XFILLER_45_14 VPWR VGND sg13g2_decap_8
XFILLER_12_525 VPWR VGND sg13g2_decap_8
XFILLER_40_878 VPWR VGND sg13g2_decap_8
Xdigitalen3.g\[3\].u.inv2 VPWR digitalen3.g\[3\].u.OUTP digitalen3.g\[3\].u.OUTN VGND
+ sg13g2_inv_1
XFILLER_20_591 VPWR VGND sg13g2_decap_8
XFILLER_4_746 VPWR VGND sg13g2_decap_8
XFILLER_10_50 VPWR VGND sg13g2_decap_8
XFILLER_3_256 VPWR VGND sg13g2_decap_8
XFILLER_16_820 VPWR VGND sg13g2_decap_4
XFILLER_16_831 VPWR VGND sg13g2_fill_1
XFILLER_19_135 VPWR VGND sg13g2_decap_8
XFILLER_34_116 VPWR VGND sg13g2_decap_8
XFILLER_43_672 VPWR VGND sg13g2_decap_8
XFILLER_47_455 VPWR VGND sg13g2_decap_8
XFILLER_30_311 VPWR VGND sg13g2_decap_8
XFILLER_31_834 VPWR VGND sg13g2_fill_2
XFILLER_42_182 VPWR VGND sg13g2_decap_8
X_1830_ net207 VGND VPWR _0162_ daisychain\[34\] clknet_leaf_11_clk sg13g2_dfrbpq_1
X_1761_ _0591_ VPWR _0349_ VGND net170 _0120_ sg13g2_o21ai_1
X_1692_ _0384_ VPWR _0280_ VGND net163 _0044_ sg13g2_o21ai_1
XFILLER_38_422 VPWR VGND sg13g2_decap_8
XFILLER_39_923 VPWR VGND sg13g2_decap_4
X_1126_ VPWR _0795_ daisychain\[94\] VGND sg13g2_inv_1
XFILLER_33_193 VPWR VGND sg13g2_decap_8
XFILLER_40_119 VPWR VGND sg13g2_decap_8
X_1057_ VPWR _0726_ daisychain\[25\] VGND sg13g2_inv_1
X_1959_ net205 VGND VPWR _0291_ state\[35\] clknet_leaf_12_clk sg13g2_dfrbpq_1
XFILLER_0_259 VPWR VGND sg13g2_decap_8
Xoutput27 net27 uo_out[1] VPWR VGND sg13g2_buf_1
Xoutput16 net16 uio_oe[6] VPWR VGND sg13g2_buf_1
XFILLER_16_105 VPWR VGND sg13g2_decap_8
XFILLER_17_628 VPWR VGND sg13g2_fill_1
XFILLER_44_469 VPWR VGND sg13g2_decap_8
XFILLER_45_926 VPWR VGND sg13g2_fill_1
XFILLER_12_311 VPWR VGND sg13g2_decap_8
XFILLER_24_171 VPWR VGND sg13g2_decap_8
XFILLER_8_326 VPWR VGND sg13g2_decap_8
XFILLER_21_71 VPWR VGND sg13g2_decap_8
XFILLER_4_543 VPWR VGND sg13g2_decap_8
Xdigitalen0.g\[0\].u.inv2 VPWR digitalen0.g\[0\].u.OUTP digitalen0.g\[0\].u.OUTN VGND
+ sg13g2_inv_1
XFILLER_0_793 VPWR VGND sg13g2_decap_8
XFILLER_36_904 VPWR VGND sg13g2_decap_8
XFILLER_47_252 VPWR VGND sg13g2_decap_8
XFILLER_48_764 VPWR VGND sg13g2_decap_8
XFILLER_35_425 VPWR VGND sg13g2_decap_8
Xclkbuf_0_clk clknet_0_clk clk VPWR VGND sg13g2_buf_16
XFILLER_30_141 VPWR VGND sg13g2_decap_8
XFILLER_31_697 VPWR VGND sg13g2_decap_4
XFILLER_7_392 VPWR VGND sg13g2_decap_8
XFILLER_7_84 VPWR VGND sg13g2_decap_8
X_1813_ net219 VGND VPWR _0145_ daisychain\[17\] clknet_leaf_9_clk sg13g2_dfrbpq_1
X_1744_ _0540_ VPWR _0332_ VGND net155 _0101_ sg13g2_o21ai_1
X_1675_ _0847_ VPWR _0263_ VGND net178 _0105_ sg13g2_o21ai_1
XFILLER_26_27 VPWR VGND sg13g2_decap_8
XFILLER_38_252 VPWR VGND sg13g2_decap_8
XFILLER_39_753 VPWR VGND sg13g2_decap_4
XFILLER_42_918 VPWR VGND sg13g2_decap_8
X_1109_ VPWR _0778_ daisychain\[77\] VGND sg13g2_inv_1
XFILLER_10_815 VPWR VGND sg13g2_decap_8
XFILLER_10_859 VPWR VGND sg13g2_fill_1
XFILLER_21_141 VPWR VGND sg13g2_decap_8
XFILLER_18_915 VPWR VGND sg13g2_decap_8
XFILLER_18_926 VPWR VGND sg13g2_fill_1
XFILLER_1_557 VPWR VGND sg13g2_decap_8
XFILLER_49_506 VPWR VGND sg13g2_decap_8
XFILLER_44_266 VPWR VGND sg13g2_decap_8
XFILLER_45_756 VPWR VGND sg13g2_decap_8
Xdigitalen1.g\[2\].u.inv1 VPWR digitalen1.g\[2\].u.OUTN net7 VGND sg13g2_inv_1
XFILLER_9_602 VPWR VGND sg13g2_decap_8
XFILLER_12_185 VPWR VGND sg13g2_decap_8
XFILLER_13_686 VPWR VGND sg13g2_decap_4
XFILLER_32_81 VPWR VGND sg13g2_decap_8
XFILLER_40_483 VPWR VGND sg13g2_decap_8
XFILLER_5_830 VPWR VGND sg13g2_decap_8
XFILLER_8_123 VPWR VGND sg13g2_decap_8
XFILLER_9_635 VPWR VGND sg13g2_decap_8
XFILLER_4_340 VPWR VGND sg13g2_decap_8
X_1460_ net157 VPWR _0539_ VGND net111 state\[76\] sg13g2_o21ai_1
X_1391_ _0186_ _0486_ _0487_ net39 _0759_ VPWR VGND sg13g2_a22oi_1
XFILLER_35_200 VPWR VGND sg13g2_decap_8
XFILLER_36_745 VPWR VGND sg13g2_decap_8
X_2012_ net212 VGND VPWR _0344_ state\[88\] clknet_leaf_4_clk sg13g2_dfrbpq_1
XFILLER_35_277 VPWR VGND sg13g2_decap_8
X_1727_ _0489_ VPWR _0315_ VGND net148 _0082_ sg13g2_o21ai_1
X_1658_ VGND VPWR net78 daisychain\[124\] _0688_ net34 sg13g2_a21oi_1
X_1589_ _0809_ net139 _0635_ _0636_ VPWR VGND sg13g2_a21o_1
XFILLER_14_439 VPWR VGND sg13g2_decap_8
XFILLER_41_203 VPWR VGND sg13g2_decap_8
XFILLER_42_715 VPWR VGND sg13g2_fill_1
XFILLER_10_656 VPWR VGND sg13g2_fill_2
XFILLER_5_137 VPWR VGND sg13g2_decap_8
XFILLER_6_627 VPWR VGND sg13g2_decap_8
XFILLER_1_343 VPWR VGND sg13g2_decap_8
XFILLER_2_844 VPWR VGND sg13g2_decap_8
XFILLER_17_244 VPWR VGND sg13g2_fill_2
XFILLER_18_734 VPWR VGND sg13g2_decap_8
XFILLER_45_553 VPWR VGND sg13g2_decap_8
XFILLER_49_347 VPWR VGND sg13g2_decap_8
XFILLER_17_288 VPWR VGND sg13g2_fill_1
XFILLER_32_214 VPWR VGND sg13g2_decap_8
XFILLER_40_280 VPWR VGND sg13g2_decap_8
XFILLER_43_91 VPWR VGND sg13g2_decap_8
XFILLER_9_443 VPWR VGND sg13g2_decap_8
X_0960_ VPWR _0076_ state\[53\] VGND sg13g2_inv_1
X_1512_ net167 VPWR _0578_ VGND net123 state\[89\] sg13g2_o21ai_1
XFILLER_49_870 VPWR VGND sg13g2_decap_8
XFILLER_4_74 VPWR VGND sg13g2_decap_8
X_1443_ _0199_ _0525_ _0526_ net43 _0772_ VPWR VGND sg13g2_a22oi_1
X_1374_ VGND VPWR net80 daisychain\[53\] _0475_ net40 sg13g2_a21oi_1
XFILLER_11_409 VPWR VGND sg13g2_decap_4
XFILLER_32_792 VPWR VGND sg13g2_fill_2
XFILLER_48_14 VPWR VGND sg13g2_decap_8
XFILLER_14_236 VPWR VGND sg13g2_decap_8
XFILLER_15_715 VPWR VGND sg13g2_fill_1
XFILLER_42_523 VPWR VGND sg13g2_decap_8
Xfanout73 net77 net73 VPWR VGND sg13g2_buf_1
Xfanout62 net63 net62 VPWR VGND sg13g2_buf_1
Xfanout51 net63 net51 VPWR VGND sg13g2_buf_1
Xfanout40 net42 net40 VPWR VGND sg13g2_buf_1
XFILLER_6_424 VPWR VGND sg13g2_decap_8
Xfanout95 net99 net95 VPWR VGND sg13g2_buf_1
Xfanout84 net99 net84 VPWR VGND sg13g2_buf_1
XFILLER_1_140 VPWR VGND sg13g2_decap_8
XFILLER_29_8 VPWR VGND sg13g2_fill_1
XFILLER_2_641 VPWR VGND sg13g2_decap_8
XFILLER_49_144 VPWR VGND sg13g2_decap_8
XFILLER_18_520 VPWR VGND sg13g2_decap_8
XFILLER_18_564 VPWR VGND sg13g2_fill_1
XFILLER_33_501 VPWR VGND sg13g2_fill_1
XFILLER_37_339 VPWR VGND sg13g2_fill_1
XFILLER_38_91 VPWR VGND sg13g2_decap_8
XFILLER_45_350 VPWR VGND sg13g2_decap_8
XFILLER_46_840 VPWR VGND sg13g2_decap_8
X_1090_ VPWR _0759_ daisychain\[58\] VGND sg13g2_inv_1
XFILLER_9_284 VPWR VGND sg13g2_decap_8
Xclkload10 clkload10/Y clknet_leaf_10_clk VPWR VGND sg13g2_inv_2
X_1992_ net198 VGND VPWR _0324_ state\[68\] clknet_leaf_1_clk sg13g2_dfrbpq_1
X_0943_ VPWR _0057_ state\[36\] VGND sg13g2_inv_1
XFILLER_48_0 VPWR VGND sg13g2_decap_8
X_1426_ VGND VPWR net79 daisychain\[66\] _0514_ net37 sg13g2_a21oi_1
X_1357_ _0751_ net106 _0461_ _0462_ VPWR VGND sg13g2_a21o_1
X_1288_ net165 VPWR _0410_ VGND net120 state\[33\] sg13g2_o21ai_1
Xclkload4 clkload4/Y clknet_leaf_15_clk VPWR VGND sg13g2_inv_8
XFILLER_3_438 VPWR VGND sg13g2_decap_8
Xfanout230 net231 net230 VPWR VGND sg13g2_buf_1
XFILLER_15_545 VPWR VGND sg13g2_fill_1
XFILLER_43_854 VPWR VGND sg13g2_decap_8
XFILLER_46_147 VPWR VGND sg13g2_decap_8
XFILLER_47_637 VPWR VGND sg13g2_decap_8
XFILLER_30_526 VPWR VGND sg13g2_decap_8
XFILLER_42_364 VPWR VGND sg13g2_decap_8
XFILLER_40_70 VPWR VGND sg13g2_decap_8
XFILLER_41_7 VPWR VGND sg13g2_decap_8
XFILLER_6_221 VPWR VGND sg13g2_decap_8
XFILLER_6_298 VPWR VGND sg13g2_decap_8
XFILLER_1_42 VPWR VGND sg13g2_decap_8
XFILLER_37_147 VPWR VGND sg13g2_decap_8
XFILLER_38_637 VPWR VGND sg13g2_decap_8
X_1211_ _0141_ _0865_ _0866_ net70 _0714_ VPWR VGND sg13g2_a22oi_1
X_1142_ VPWR _0811_ daisychain\[110\] VGND sg13g2_inv_1
XFILLER_34_843 VPWR VGND sg13g2_decap_4
XFILLER_34_898 VPWR VGND sg13g2_fill_2
X_1073_ VPWR _0742_ daisychain\[41\] VGND sg13g2_inv_1
X_1975_ net195 VGND VPWR _0307_ state\[51\] clknet_leaf_15_clk sg13g2_dfrbpq_1
X_0926_ VPWR _0038_ state\[19\] VGND sg13g2_inv_1
XFILLER_29_27 VPWR VGND sg13g2_decap_8
X_1409_ _0764_ net104 _0500_ _0501_ VPWR VGND sg13g2_a21o_1
XFILLER_28_147 VPWR VGND sg13g2_decap_8
XFILLER_12_537 VPWR VGND sg13g2_fill_1
XFILLER_20_570 VPWR VGND sg13g2_decap_8
XFILLER_40_857 VPWR VGND sg13g2_decap_8
XFILLER_3_235 VPWR VGND sg13g2_decap_8
XFILLER_4_725 VPWR VGND sg13g2_decap_8
XFILLER_19_114 VPWR VGND sg13g2_decap_8
XFILLER_47_434 VPWR VGND sg13g2_decap_8
XFILLER_19_158 VPWR VGND sg13g2_fill_1
XFILLER_19_93 VPWR VGND sg13g2_decap_8
XFILLER_30_301 VPWR VGND sg13g2_fill_1
XFILLER_35_81 VPWR VGND sg13g2_decap_8
XFILLER_42_161 VPWR VGND sg13g2_decap_8
XFILLER_43_651 VPWR VGND sg13g2_decap_8
XFILLER_43_695 VPWR VGND sg13g2_fill_1
XFILLER_31_868 VPWR VGND sg13g2_fill_2
XFILLER_7_530 VPWR VGND sg13g2_decap_8
XFILLER_7_585 VPWR VGND sg13g2_decap_8
X_1760_ _0588_ VPWR _0348_ VGND net167 _0119_ sg13g2_o21ai_1
X_1691_ _0895_ VPWR _0279_ VGND net174 _0043_ sg13g2_o21ai_1
XFILLER_39_902 VPWR VGND sg13g2_decap_8
XFILLER_25_139 VPWR VGND sg13g2_decap_8
X_1125_ VPWR _0794_ daisychain\[93\] VGND sg13g2_inv_1
XFILLER_33_172 VPWR VGND sg13g2_decap_8
X_1056_ VPWR _0725_ daisychain\[24\] VGND sg13g2_inv_1
XFILLER_31_39 VPWR VGND sg13g2_decap_8
Xoutput28 net28 uo_out[2] VPWR VGND sg13g2_buf_1
Xoutput17 net17 uio_oe[7] VPWR VGND sg13g2_buf_1
X_1958_ net205 VGND VPWR _0290_ state\[34\] clknet_leaf_13_clk sg13g2_dfrbpq_1
X_1889_ net215 VGND VPWR _0221_ daisychain\[93\] clknet_leaf_4_clk sg13g2_dfrbpq_1
X_0909_ VPWR _0050_ state\[2\] VGND sg13g2_inv_1
XFILLER_0_238 VPWR VGND sg13g2_decap_8
XFILLER_1_739 VPWR VGND sg13g2_decap_8
XFILLER_17_607 VPWR VGND sg13g2_decap_8
XFILLER_24_150 VPWR VGND sg13g2_decap_8
XFILLER_31_109 VPWR VGND sg13g2_decap_8
XFILLER_44_448 VPWR VGND sg13g2_decap_8
XFILLER_8_305 VPWR VGND sg13g2_decap_8
XFILLER_21_50 VPWR VGND sg13g2_decap_8
XFILLER_4_522 VPWR VGND sg13g2_decap_8
XFILLER_4_599 VPWR VGND sg13g2_decap_8
XFILLER_0_772 VPWR VGND sg13g2_decap_8
XFILLER_47_231 VPWR VGND sg13g2_decap_8
XFILLER_48_721 VPWR VGND sg13g2_decap_8
XFILLER_48_732 VPWR VGND sg13g2_fill_1
XFILLER_48_743 VPWR VGND sg13g2_decap_8
XFILLER_15_194 VPWR VGND sg13g2_decap_8
XFILLER_16_695 VPWR VGND sg13g2_decap_8
XFILLER_22_109 VPWR VGND sg13g2_decap_8
XFILLER_30_120 VPWR VGND sg13g2_decap_8
XFILLER_46_91 VPWR VGND sg13g2_decap_8
XFILLER_30_197 VPWR VGND sg13g2_decap_8
XFILLER_7_371 VPWR VGND sg13g2_decap_8
XFILLER_7_63 VPWR VGND sg13g2_decap_8
X_1812_ net219 VGND VPWR _0144_ daisychain\[16\] clknet_leaf_9_clk sg13g2_dfrbpq_1
X_1743_ _0537_ VPWR _0331_ VGND net155 _0100_ sg13g2_o21ai_1
X_1674_ _0844_ VPWR _0262_ VGND net178 _0094_ sg13g2_o21ai_1
XFILLER_38_231 VPWR VGND sg13g2_decap_8
X_1108_ VPWR _0777_ daisychain\[76\] VGND sg13g2_inv_1
X_1039_ VPWR _0708_ daisychain\[7\] VGND sg13g2_inv_1
XFILLER_21_120 VPWR VGND sg13g2_decap_8
XFILLER_21_197 VPWR VGND sg13g2_decap_8
XFILLER_42_49 VPWR VGND sg13g2_decap_8
XFILLER_5_319 VPWR VGND sg13g2_decap_8
XFILLER_1_536 VPWR VGND sg13g2_decap_8
XFILLER_45_735 VPWR VGND sg13g2_decap_8
XFILLER_44_245 VPWR VGND sg13g2_decap_8
XFILLER_8_102 VPWR VGND sg13g2_decap_8
Xdigitalen1.g\[2\].u.inv2 VPWR digitalen1.g\[2\].u.OUTP digitalen1.g\[2\].u.OUTN VGND
+ sg13g2_inv_1
XFILLER_12_164 VPWR VGND sg13g2_decap_8
XFILLER_13_698 VPWR VGND sg13g2_fill_2
XFILLER_32_60 VPWR VGND sg13g2_decap_8
XFILLER_8_179 VPWR VGND sg13g2_decap_8
XFILLER_9_669 VPWR VGND sg13g2_decap_8
XFILLER_9_647 VPWR VGND sg13g2_fill_1
XFILLER_4_396 VPWR VGND sg13g2_decap_8
XFILLER_5_886 VPWR VGND sg13g2_decap_8
X_1390_ VGND VPWR net81 daisychain\[57\] _0487_ net39 sg13g2_a21oi_1
XFILLER_35_256 VPWR VGND sg13g2_decap_8
XFILLER_48_595 VPWR VGND sg13g2_decap_8
X_2011_ net211 VGND VPWR _0343_ state\[87\] clknet_leaf_4_clk sg13g2_dfrbpq_1
XFILLER_8_691 VPWR VGND sg13g2_fill_1
X_1726_ _0486_ VPWR _0314_ VGND net149 _0081_ sg13g2_o21ai_1
X_1657_ net100 _0697_ _0686_ _0687_ VPWR VGND sg13g2_a21o_1
X_1588_ net183 VPWR _0635_ VGND net139 state\[108\] sg13g2_o21ai_1
XFILLER_26_201 VPWR VGND sg13g2_decap_8
XFILLER_37_49 VPWR VGND sg13g2_decap_8
XFILLER_14_407 VPWR VGND sg13g2_fill_2
XFILLER_26_256 VPWR VGND sg13g2_fill_2
XFILLER_41_259 VPWR VGND sg13g2_decap_8
XFILLER_10_646 VPWR VGND sg13g2_decap_4
XFILLER_5_116 VPWR VGND sg13g2_decap_8
XFILLER_6_606 VPWR VGND sg13g2_decap_8
XFILLER_1_322 VPWR VGND sg13g2_decap_8
XFILLER_1_399 VPWR VGND sg13g2_fill_1
XFILLER_2_823 VPWR VGND sg13g2_decap_8
XFILLER_49_326 VPWR VGND sg13g2_decap_8
XFILLER_17_223 VPWR VGND sg13g2_decap_8
XFILLER_27_93 VPWR VGND sg13g2_decap_8
XFILLER_45_532 VPWR VGND sg13g2_decap_8
Xclkbuf_2_0__f_clk clknet_2_0__leaf_clk clknet_0_clk VPWR VGND sg13g2_buf_16
XFILLER_43_70 VPWR VGND sg13g2_decap_8
XFILLER_9_422 VPWR VGND sg13g2_decap_8
XFILLER_4_193 VPWR VGND sg13g2_decap_8
XFILLER_5_683 VPWR VGND sg13g2_decap_8
X_1511_ _0216_ _0576_ _0577_ net57 _0789_ VPWR VGND sg13g2_a22oi_1
X_1442_ VGND VPWR net83 daisychain\[70\] _0526_ net43 sg13g2_a21oi_1
XFILLER_9_499 VPWR VGND sg13g2_fill_2
XFILLER_4_53 VPWR VGND sg13g2_decap_8
X_1373_ _0755_ net106 _0473_ _0474_ VPWR VGND sg13g2_a21o_1
XFILLER_23_226 VPWR VGND sg13g2_fill_2
XFILLER_48_392 VPWR VGND sg13g2_decap_8
XFILLER_31_270 VPWR VGND sg13g2_decap_8
X_1709_ _0435_ VPWR _0297_ VGND net160 _0063_ sg13g2_o21ai_1
XFILLER_42_502 VPWR VGND sg13g2_decap_4
XFILLER_46_329 VPWR VGND sg13g2_decap_8
XFILLER_47_819 VPWR VGND sg13g2_decap_8
XFILLER_14_215 VPWR VGND sg13g2_decap_8
Xfanout96 net98 net96 VPWR VGND sg13g2_buf_1
Xfanout85 net86 net85 VPWR VGND sg13g2_buf_1
Xfanout74 net76 net74 VPWR VGND sg13g2_buf_1
Xfanout63 net77 net63 VPWR VGND sg13g2_buf_1
Xfanout52 net54 net52 VPWR VGND sg13g2_buf_1
Xfanout41 net42 net41 VPWR VGND sg13g2_buf_1
XFILLER_10_454 VPWR VGND sg13g2_decap_8
XFILLER_2_620 VPWR VGND sg13g2_decap_8
XFILLER_6_403 VPWR VGND sg13g2_decap_8
XFILLER_1_196 VPWR VGND sg13g2_decap_8
XFILLER_2_697 VPWR VGND sg13g2_decap_8
XFILLER_38_70 VPWR VGND sg13g2_decap_8
XFILLER_49_123 VPWR VGND sg13g2_decap_8
XFILLER_46_896 VPWR VGND sg13g2_decap_8
XFILLER_9_263 VPWR VGND sg13g2_decap_8
Xclkload11 VPWR clkload11/Y clknet_leaf_4_clk VGND sg13g2_inv_1
X_1991_ net198 VGND VPWR _0323_ state\[67\] clknet_leaf_1_clk sg13g2_dfrbpq_1
X_0942_ VPWR _0056_ state\[35\] VGND sg13g2_inv_1
XFILLER_5_480 VPWR VGND sg13g2_decap_8
X_1425_ _0768_ net109 _0512_ _0513_ VPWR VGND sg13g2_a21o_1
XFILLER_37_863 VPWR VGND sg13g2_fill_2
X_1356_ net150 VPWR _0461_ VGND net106 state\[50\] sg13g2_o21ai_1
X_1287_ _0160_ _0408_ _0409_ net55 _0733_ VPWR VGND sg13g2_a22oi_1
XFILLER_34_39 VPWR VGND sg13g2_decap_8
Xclkload5 clknet_leaf_16_clk clkload5/Y VPWR VGND sg13g2_inv_16
XFILLER_3_417 VPWR VGND sg13g2_decap_8
XFILLER_4_907 VPWR VGND sg13g2_decap_8
XFILLER_19_318 VPWR VGND sg13g2_fill_2
XFILLER_1_7 VPWR VGND sg13g2_decap_8
XFILLER_47_616 VPWR VGND sg13g2_decap_8
Xfanout220 net223 net220 VPWR VGND sg13g2_buf_1
Xfanout231 net1 net231 VPWR VGND sg13g2_buf_1
XFILLER_15_502 VPWR VGND sg13g2_fill_1
XFILLER_42_343 VPWR VGND sg13g2_decap_8
XFILLER_43_833 VPWR VGND sg13g2_decap_8
XFILLER_46_126 VPWR VGND sg13g2_decap_8
XFILLER_10_295 VPWR VGND sg13g2_decap_8
XFILLER_11_763 VPWR VGND sg13g2_decap_8
XFILLER_24_94 VPWR VGND sg13g2_decap_8
XFILLER_30_505 VPWR VGND sg13g2_decap_8
XFILLER_30_516 VPWR VGND sg13g2_decap_4
XFILLER_6_200 VPWR VGND sg13g2_decap_8
XFILLER_6_277 VPWR VGND sg13g2_decap_8
XFILLER_1_21 VPWR VGND sg13g2_decap_8
XFILLER_1_98 VPWR VGND sg13g2_decap_8
XFILLER_2_494 VPWR VGND sg13g2_decap_8
XFILLER_37_126 VPWR VGND sg13g2_decap_8
X_1210_ VGND VPWR net93 daisychain\[12\] _0866_ net68 sg13g2_a21oi_1
X_1141_ VPWR _0810_ daisychain\[109\] VGND sg13g2_inv_1
X_1072_ VPWR _0741_ daisychain\[40\] VGND sg13g2_inv_1
XFILLER_33_387 VPWR VGND sg13g2_decap_8
XFILLER_46_693 VPWR VGND sg13g2_decap_8
X_1974_ net196 VGND VPWR _0306_ state\[50\] clknet_leaf_14_clk sg13g2_dfrbpq_1
X_0925_ VPWR _0037_ state\[18\] VGND sg13g2_inv_1
X_1408_ net148 VPWR _0500_ VGND net104 state\[63\] sg13g2_o21ai_1
XFILLER_28_126 VPWR VGND sg13g2_decap_8
XFILLER_45_49 VPWR VGND sg13g2_decap_8
X_1339_ _0173_ _0447_ _0448_ net50 _0746_ VPWR VGND sg13g2_a22oi_1
XFILLER_12_505 VPWR VGND sg13g2_fill_1
XFILLER_40_847 VPWR VGND sg13g2_fill_1
XFILLER_10_85 VPWR VGND sg13g2_decap_8
XFILLER_3_214 VPWR VGND sg13g2_decap_8
XFILLER_4_704 VPWR VGND sg13g2_decap_8
XFILLER_19_72 VPWR VGND sg13g2_decap_8
XFILLER_47_413 VPWR VGND sg13g2_decap_8
XFILLER_48_925 VPWR VGND sg13g2_fill_2
XFILLER_15_376 VPWR VGND sg13g2_decap_8
XFILLER_15_398 VPWR VGND sg13g2_fill_1
XFILLER_16_811 VPWR VGND sg13g2_fill_1
XFILLER_27_170 VPWR VGND sg13g2_decap_8
XFILLER_31_836 VPWR VGND sg13g2_fill_1
XFILLER_31_858 VPWR VGND sg13g2_decap_4
XFILLER_35_60 VPWR VGND sg13g2_decap_8
XFILLER_42_140 VPWR VGND sg13g2_decap_8
XFILLER_43_630 VPWR VGND sg13g2_decap_8
XFILLER_7_553 VPWR VGND sg13g2_decap_8
X_1690_ _0892_ VPWR _0278_ VGND net174 _0042_ sg13g2_o21ai_1
XFILLER_2_291 VPWR VGND sg13g2_decap_8
XFILLER_32_4 VPWR VGND sg13g2_decap_8
XFILLER_3_781 VPWR VGND sg13g2_decap_8
XFILLER_18_181 VPWR VGND sg13g2_decap_8
XFILLER_25_118 VPWR VGND sg13g2_decap_8
XFILLER_46_490 VPWR VGND sg13g2_decap_8
X_1124_ VPWR _0793_ daisychain\[92\] VGND sg13g2_inv_1
X_1055_ VPWR _0724_ daisychain\[23\] VGND sg13g2_inv_1
XFILLER_31_18 VPWR VGND sg13g2_decap_8
XFILLER_33_151 VPWR VGND sg13g2_decap_8
X_1957_ net206 VGND VPWR _0289_ state\[33\] clknet_leaf_13_clk sg13g2_dfrbpq_1
XFILLER_0_217 VPWR VGND sg13g2_decap_8
XFILLER_1_718 VPWR VGND sg13g2_decap_8
Xoutput29 net29 uo_out[3] VPWR VGND sg13g2_buf_1
Xoutput18 net18 uio_out[0] VPWR VGND sg13g2_buf_1
X_1888_ net215 VGND VPWR _0220_ daisychain\[92\] clknet_leaf_4_clk sg13g2_dfrbpq_1
X_0908_ VPWR _0039_ state\[1\] VGND sg13g2_inv_1
XFILLER_45_917 VPWR VGND sg13g2_decap_8
XFILLER_13_836 VPWR VGND sg13g2_decap_8
XFILLER_44_427 VPWR VGND sg13g2_decap_8
XFILLER_12_346 VPWR VGND sg13g2_decap_4
XFILLER_12_368 VPWR VGND sg13g2_decap_8
XFILLER_12_379 VPWR VGND sg13g2_decap_8
XFILLER_4_501 VPWR VGND sg13g2_decap_8
XFILLER_0_751 VPWR VGND sg13g2_decap_8
XFILLER_48_700 VPWR VGND sg13g2_decap_8
XFILLER_4_578 VPWR VGND sg13g2_decap_8
XFILLER_46_70 VPWR VGND sg13g2_decap_8
XFILLER_47_210 VPWR VGND sg13g2_decap_8
XFILLER_47_287 VPWR VGND sg13g2_decap_8
XFILLER_48_799 VPWR VGND sg13g2_decap_8
XFILLER_15_173 VPWR VGND sg13g2_decap_8
XFILLER_30_176 VPWR VGND sg13g2_decap_8
X_1811_ net219 VGND VPWR _0143_ daisychain\[15\] clknet_leaf_9_clk sg13g2_dfrbpq_1
XFILLER_7_350 VPWR VGND sg13g2_decap_8
XFILLER_7_42 VPWR VGND sg13g2_decap_8
X_1742_ _0534_ VPWR _0330_ VGND net155 _0099_ sg13g2_o21ai_1
X_1673_ _0841_ VPWR _0261_ VGND net178 _0083_ sg13g2_o21ai_1
XFILLER_38_210 VPWR VGND sg13g2_decap_8
XFILLER_38_287 VPWR VGND sg13g2_decap_8
X_1107_ VPWR _0776_ daisychain\[75\] VGND sg13g2_inv_1
X_1038_ VPWR _0707_ daisychain\[6\] VGND sg13g2_inv_1
XFILLER_21_176 VPWR VGND sg13g2_decap_8
XFILLER_42_28 VPWR VGND sg13g2_decap_8
XFILLER_1_515 VPWR VGND sg13g2_decap_8
XFILLER_17_449 VPWR VGND sg13g2_decap_8
XFILLER_44_224 VPWR VGND sg13g2_decap_8
XFILLER_45_714 VPWR VGND sg13g2_decap_8
XFILLER_12_143 VPWR VGND sg13g2_decap_8
XFILLER_16_84 VPWR VGND sg13g2_decap_8
XFILLER_40_463 VPWR VGND sg13g2_fill_2
XFILLER_41_920 VPWR VGND sg13g2_decap_8
XFILLER_4_375 VPWR VGND sg13g2_decap_8
XFILLER_5_865 VPWR VGND sg13g2_decap_8
XFILLER_8_158 VPWR VGND sg13g2_decap_8
X_2010_ net212 VGND VPWR _0342_ state\[86\] clknet_leaf_5_clk sg13g2_dfrbpq_1
XFILLER_35_235 VPWR VGND sg13g2_decap_8
XFILLER_48_574 VPWR VGND sg13g2_decap_8
X_1725_ _0483_ VPWR _0313_ VGND net149 _0080_ sg13g2_o21ai_1
Xclkbuf_leaf_7_clk clknet_2_3__leaf_clk clknet_leaf_7_clk VPWR VGND sg13g2_buf_8
X_1656_ net146 VPWR _0686_ VGND state\[125\] net101 sg13g2_o21ai_1
X_1587_ _0235_ _0633_ _0634_ net71 _0808_ VPWR VGND sg13g2_a22oi_1
XFILLER_37_28 VPWR VGND sg13g2_decap_8
XFILLER_39_563 VPWR VGND sg13g2_decap_8
XFILLER_41_238 VPWR VGND sg13g2_decap_8
XFILLER_42_706 VPWR VGND sg13g2_fill_2
XFILLER_10_658 VPWR VGND sg13g2_fill_1
XFILLER_1_301 VPWR VGND sg13g2_decap_8
XFILLER_2_802 VPWR VGND sg13g2_decap_8
XFILLER_1_378 VPWR VGND sg13g2_decap_8
XFILLER_2_879 VPWR VGND sg13g2_decap_8
XFILLER_49_305 VPWR VGND sg13g2_decap_8
XFILLER_17_202 VPWR VGND sg13g2_decap_8
XFILLER_18_758 VPWR VGND sg13g2_fill_2
XFILLER_27_72 VPWR VGND sg13g2_decap_8
XFILLER_45_511 VPWR VGND sg13g2_decap_8
XFILLER_45_588 VPWR VGND sg13g2_decap_8
XFILLER_41_794 VPWR VGND sg13g2_decap_8
XFILLER_9_478 VPWR VGND sg13g2_fill_1
XFILLER_4_172 VPWR VGND sg13g2_decap_8
XFILLER_4_32 VPWR VGND sg13g2_decap_8
XFILLER_5_662 VPWR VGND sg13g2_decap_8
X_1510_ VGND VPWR net90 daisychain\[87\] _0577_ net57 sg13g2_a21oi_1
X_1441_ _0772_ net113 _0524_ _0525_ VPWR VGND sg13g2_a21o_1
XFILLER_48_371 VPWR VGND sg13g2_decap_8
X_1372_ net150 VPWR _0473_ VGND net106 state\[54\] sg13g2_o21ai_1
XFILLER_32_794 VPWR VGND sg13g2_fill_1
XFILLER_2_109 VPWR VGND sg13g2_decap_8
X_1708_ _0432_ VPWR _0296_ VGND net162 _0062_ sg13g2_o21ai_1
XFILLER_48_49 VPWR VGND sg13g2_decap_8
X_1639_ _0248_ _0672_ _0673_ net76 _0821_ VPWR VGND sg13g2_a22oi_1
XFILLER_46_308 VPWR VGND sg13g2_decap_8
XFILLER_10_433 VPWR VGND sg13g2_decap_8
XFILLER_7_916 VPWR VGND sg13g2_decap_8
Xfanout97 net98 net97 VPWR VGND sg13g2_buf_1
Xfanout86 net91 net86 VPWR VGND sg13g2_buf_1
Xfanout75 net76 net75 VPWR VGND sg13g2_buf_1
Xfanout64 net66 net64 VPWR VGND sg13g2_buf_1
Xfanout53 net54 net53 VPWR VGND sg13g2_buf_1
Xfanout42 net48 net42 VPWR VGND sg13g2_buf_1
XFILLER_10_488 VPWR VGND sg13g2_fill_1
XFILLER_2_676 VPWR VGND sg13g2_decap_8
XFILLER_6_459 VPWR VGND sg13g2_decap_8
XFILLER_18_500 VPWR VGND sg13g2_decap_8
XFILLER_18_511 VPWR VGND sg13g2_fill_2
XFILLER_1_175 VPWR VGND sg13g2_decap_8
XFILLER_37_308 VPWR VGND sg13g2_decap_8
XFILLER_49_102 VPWR VGND sg13g2_decap_8
XFILLER_49_179 VPWR VGND sg13g2_decap_8
XFILLER_33_514 VPWR VGND sg13g2_decap_8
XFILLER_33_525 VPWR VGND sg13g2_fill_2
XFILLER_45_385 VPWR VGND sg13g2_decap_8
XFILLER_46_875 VPWR VGND sg13g2_decap_8
X_1990_ net198 VGND VPWR _0322_ state\[66\] clknet_leaf_1_clk sg13g2_dfrbpq_1
X_0941_ VPWR _0055_ state\[34\] VGND sg13g2_inv_1
XFILLER_13_282 VPWR VGND sg13g2_fill_2
XFILLER_9_242 VPWR VGND sg13g2_decap_8
Xclkload12 clkload12/Y clknet_leaf_5_clk VPWR VGND sg13g2_inv_2
X_1424_ net153 VPWR _0512_ VGND net109 state\[67\] sg13g2_o21ai_1
X_1355_ _0177_ _0459_ _0460_ net42 _0750_ VPWR VGND sg13g2_a22oi_1
XFILLER_34_18 VPWR VGND sg13g2_decap_8
XFILLER_36_396 VPWR VGND sg13g2_fill_1
XFILLER_49_680 VPWR VGND sg13g2_decap_8
X_1286_ VGND VPWR net86 daisychain\[31\] _0409_ net55 sg13g2_a21oi_1
XFILLER_11_219 VPWR VGND sg13g2_decap_8
XFILLER_20_764 VPWR VGND sg13g2_fill_2
XFILLER_32_591 VPWR VGND sg13g2_fill_2
Xclkload6 clkload6/Y clknet_leaf_0_clk VPWR VGND sg13g2_inv_2
XFILLER_46_105 VPWR VGND sg13g2_decap_8
Xfanout210 net231 net210 VPWR VGND sg13g2_buf_1
Xfanout221 net223 net221 VPWR VGND sg13g2_buf_1
XFILLER_15_558 VPWR VGND sg13g2_fill_1
XFILLER_15_569 VPWR VGND sg13g2_decap_4
XFILLER_42_322 VPWR VGND sg13g2_decap_8
XFILLER_43_812 VPWR VGND sg13g2_decap_8
XFILLER_43_889 VPWR VGND sg13g2_decap_8
XFILLER_10_274 VPWR VGND sg13g2_decap_8
XFILLER_42_399 VPWR VGND sg13g2_decap_8
XFILLER_6_256 VPWR VGND sg13g2_decap_8
XFILLER_7_768 VPWR VGND sg13g2_decap_8
XFILLER_27_7 VPWR VGND sg13g2_fill_2
XFILLER_2_473 VPWR VGND sg13g2_decap_8
XFILLER_49_81 VPWR VGND sg13g2_decap_8
Xdigitalen0.g\[3\].u.inv1 VPWR digitalen0.g\[3\].u.OUTN net6 VGND sg13g2_inv_1
XFILLER_18_385 VPWR VGND sg13g2_decap_8
XFILLER_19_886 VPWR VGND sg13g2_fill_2
XFILLER_1_77 VPWR VGND sg13g2_decap_8
XFILLER_33_300 VPWR VGND sg13g2_decap_4
XFILLER_37_105 VPWR VGND sg13g2_decap_8
XFILLER_38_606 VPWR VGND sg13g2_fill_1
XFILLER_46_672 VPWR VGND sg13g2_decap_8
X_1140_ VPWR _0809_ daisychain\[108\] VGND sg13g2_inv_1
X_1071_ VPWR _0740_ daisychain\[39\] VGND sg13g2_inv_1
XFILLER_45_182 VPWR VGND sg13g2_decap_8
X_1973_ net196 VGND VPWR _0305_ state\[49\] clknet_leaf_14_clk sg13g2_dfrbpq_1
X_0924_ VPWR _0036_ state\[17\] VGND sg13g2_inv_1
XFILLER_6_790 VPWR VGND sg13g2_decap_8
XFILLER_28_105 VPWR VGND sg13g2_decap_8
X_1407_ _0190_ _0498_ _0499_ net36 _0763_ VPWR VGND sg13g2_a22oi_1
X_1338_ VGND VPWR net80 daisychain\[44\] _0448_ net40 sg13g2_a21oi_1
XFILLER_36_193 VPWR VGND sg13g2_decap_8
XFILLER_40_804 VPWR VGND sg13g2_decap_8
XFILLER_43_119 VPWR VGND sg13g2_decap_8
XFILLER_44_609 VPWR VGND sg13g2_decap_8
XFILLER_45_28 VPWR VGND sg13g2_decap_8
X_1269_ _0729_ net121 _0395_ _0396_ VPWR VGND sg13g2_a21o_1
XFILLER_0_911 VPWR VGND sg13g2_decap_8
XFILLER_10_64 VPWR VGND sg13g2_decap_8
XFILLER_48_904 VPWR VGND sg13g2_decap_8
XFILLER_15_311 VPWR VGND sg13g2_decap_8
XFILLER_19_149 VPWR VGND sg13g2_decap_8
XFILLER_19_51 VPWR VGND sg13g2_decap_8
XFILLER_47_469 VPWR VGND sg13g2_decap_8
XFILLER_30_347 VPWR VGND sg13g2_decap_4
XFILLER_42_196 VPWR VGND sg13g2_decap_8
XFILLER_43_686 VPWR VGND sg13g2_decap_8
XFILLER_11_594 VPWR VGND sg13g2_decap_8
XFILLER_25_4 VPWR VGND sg13g2_decap_4
XFILLER_2_270 VPWR VGND sg13g2_decap_8
XFILLER_38_403 VPWR VGND sg13g2_fill_2
XFILLER_38_436 VPWR VGND sg13g2_decap_8
XFILLER_38_447 VPWR VGND sg13g2_fill_1
XFILLER_3_760 VPWR VGND sg13g2_decap_8
XFILLER_18_160 VPWR VGND sg13g2_decap_8
XFILLER_33_130 VPWR VGND sg13g2_decap_8
XFILLER_34_664 VPWR VGND sg13g2_decap_4
XFILLER_38_469 VPWR VGND sg13g2_decap_8
X_1123_ VPWR _0792_ daisychain\[91\] VGND sg13g2_inv_1
X_1054_ VPWR _0723_ daisychain\[22\] VGND sg13g2_inv_1
X_1956_ net210 VGND VPWR _0288_ state\[32\] clknet_leaf_13_clk sg13g2_dfrbpq_1
X_1887_ net215 VGND VPWR _0219_ daisychain\[91\] clknet_leaf_5_clk sg13g2_dfrbpq_1
X_0907_ VPWR _0000_ state\[0\] VGND sg13g2_inv_1
Xoutput19 net19 uio_out[1] VPWR VGND sg13g2_buf_1
XFILLER_16_119 VPWR VGND sg13g2_decap_8
XFILLER_44_406 VPWR VGND sg13g2_decap_8
XFILLER_12_325 VPWR VGND sg13g2_decap_8
XFILLER_24_185 VPWR VGND sg13g2_decap_8
XFILLER_20_380 VPWR VGND sg13g2_decap_8
XFILLER_21_85 VPWR VGND sg13g2_decap_8
XFILLER_4_557 VPWR VGND sg13g2_decap_8
XFILLER_0_730 VPWR VGND sg13g2_decap_8
XFILLER_15_152 VPWR VGND sg13g2_decap_8
XFILLER_16_653 VPWR VGND sg13g2_decap_4
XFILLER_35_439 VPWR VGND sg13g2_fill_2
XFILLER_36_918 VPWR VGND sg13g2_decap_8
XFILLER_47_266 VPWR VGND sg13g2_decap_8
XFILLER_48_778 VPWR VGND sg13g2_decap_8
XFILLER_12_881 VPWR VGND sg13g2_fill_1
XFILLER_30_155 VPWR VGND sg13g2_decap_8
XFILLER_43_483 VPWR VGND sg13g2_decap_8
XFILLER_7_21 VPWR VGND sg13g2_decap_8
XFILLER_8_863 VPWR VGND sg13g2_decap_8
X_1810_ net219 VGND VPWR _0142_ daisychain\[14\] clknet_leaf_9_clk sg13g2_dfrbpq_1
X_1741_ _0531_ VPWR _0329_ VGND net154 _0098_ sg13g2_o21ai_1
XFILLER_7_98 VPWR VGND sg13g2_decap_8
X_1672_ _0838_ VPWR _0260_ VGND net179 _0072_ sg13g2_o21ai_1
XFILLER_16_0 VPWR VGND sg13g2_fill_2
XFILLER_38_266 VPWR VGND sg13g2_decap_8
X_1106_ VPWR _0775_ daisychain\[74\] VGND sg13g2_inv_1
XFILLER_19_491 VPWR VGND sg13g2_fill_1
XFILLER_34_483 VPWR VGND sg13g2_decap_4
X_1037_ VPWR _0706_ daisychain\[5\] VGND sg13g2_inv_1
XFILLER_10_829 VPWR VGND sg13g2_decap_4
XFILLER_21_155 VPWR VGND sg13g2_decap_8
X_1939_ net219 VGND VPWR _0271_ state\[15\] clknet_leaf_9_clk sg13g2_dfrbpq_1
XFILLER_29_211 VPWR VGND sg13g2_fill_1
XFILLER_16_30 VPWR VGND sg13g2_decap_8
XFILLER_17_428 VPWR VGND sg13g2_decap_8
XFILLER_44_203 VPWR VGND sg13g2_decap_8
XFILLER_12_122 VPWR VGND sg13g2_decap_8
XFILLER_12_199 VPWR VGND sg13g2_decap_8
XFILLER_13_612 VPWR VGND sg13g2_decap_4
XFILLER_40_442 VPWR VGND sg13g2_decap_8
XFILLER_8_137 VPWR VGND sg13g2_decap_8
XFILLER_9_616 VPWR VGND sg13g2_decap_8
XFILLER_32_95 VPWR VGND sg13g2_decap_8
XFILLER_4_354 VPWR VGND sg13g2_decap_8
XFILLER_5_844 VPWR VGND sg13g2_decap_8
XFILLER_0_582 VPWR VGND sg13g2_decap_8
XFILLER_48_553 VPWR VGND sg13g2_decap_8
XFILLER_35_214 VPWR VGND sg13g2_decap_8
XFILLER_43_280 VPWR VGND sg13g2_decap_8
XFILLER_44_792 VPWR VGND sg13g2_decap_8
X_1724_ _0480_ VPWR _0312_ VGND net152 _0079_ sg13g2_o21ai_1
X_1655_ _0252_ _0684_ _0685_ net34 _0698_ VPWR VGND sg13g2_a22oi_1
X_1586_ VGND VPWR net96 daisychain\[106\] _0634_ net71 sg13g2_a21oi_1
X_2069_ daisychain\[121\] net27 VPWR VGND sg13g2_buf_1
XFILLER_35_792 VPWR VGND sg13g2_decap_4
XFILLER_41_217 VPWR VGND sg13g2_decap_8
XFILLER_2_858 VPWR VGND sg13g2_decap_8
XFILLER_1_357 VPWR VGND sg13g2_decap_8
XFILLER_13_431 VPWR VGND sg13g2_decap_4
XFILLER_32_228 VPWR VGND sg13g2_decap_4
XFILLER_33_718 VPWR VGND sg13g2_decap_8
XFILLER_45_567 VPWR VGND sg13g2_decap_8
XFILLER_40_294 VPWR VGND sg13g2_decap_8
XFILLER_41_773 VPWR VGND sg13g2_decap_8
XFILLER_5_641 VPWR VGND sg13g2_decap_8
XFILLER_4_11 VPWR VGND sg13g2_decap_8
XFILLER_4_151 VPWR VGND sg13g2_decap_8
XFILLER_4_88 VPWR VGND sg13g2_decap_8
X_1440_ net156 VPWR _0524_ VGND net113 state\[71\] sg13g2_o21ai_1
X_1371_ _0181_ _0471_ _0472_ net40 _0754_ VPWR VGND sg13g2_a22oi_1
XFILLER_36_523 VPWR VGND sg13g2_decap_8
XFILLER_36_545 VPWR VGND sg13g2_fill_2
XFILLER_48_350 VPWR VGND sg13g2_decap_8
XFILLER_49_884 VPWR VGND sg13g2_decap_8
XFILLER_20_913 VPWR VGND sg13g2_decap_8
XFILLER_23_206 VPWR VGND sg13g2_fill_2
X_1707_ _0429_ VPWR _0295_ VGND net161 _0060_ sg13g2_o21ai_1
X_1638_ VGND VPWR net97 daisychain\[119\] _0673_ net76 sg13g2_a21oi_1
XFILLER_48_28 VPWR VGND sg13g2_decap_8
X_1569_ _0804_ net141 _0620_ _0621_ VPWR VGND sg13g2_a21o_1
XFILLER_39_394 VPWR VGND sg13g2_decap_8
XFILLER_6_438 VPWR VGND sg13g2_decap_8
Xfanout98 net99 net98 VPWR VGND sg13g2_buf_1
Xfanout87 net91 net87 VPWR VGND sg13g2_buf_1
Xfanout76 net77 net76 VPWR VGND sg13g2_buf_1
Xfanout65 net66 net65 VPWR VGND sg13g2_buf_1
Xfanout54 net55 net54 VPWR VGND sg13g2_buf_1
Xfanout43 net48 net43 VPWR VGND sg13g2_buf_1
XFILLER_1_154 VPWR VGND sg13g2_decap_8
XFILLER_2_655 VPWR VGND sg13g2_decap_8
XFILLER_46_854 VPWR VGND sg13g2_decap_8
XFILLER_49_158 VPWR VGND sg13g2_decap_8
XFILLER_13_261 VPWR VGND sg13g2_decap_8
XFILLER_14_740 VPWR VGND sg13g2_decap_8
XFILLER_41_581 VPWR VGND sg13g2_fill_2
XFILLER_45_364 VPWR VGND sg13g2_decap_8
XFILLER_9_221 VPWR VGND sg13g2_decap_8
X_0940_ VPWR _0054_ state\[33\] VGND sg13g2_inv_1
XFILLER_9_298 VPWR VGND sg13g2_decap_8
Xclkload13 VPWR clkload13/Y clknet_leaf_6_clk VGND sg13g2_inv_1
X_1423_ _0194_ _0510_ _0511_ net37 _0767_ VPWR VGND sg13g2_a22oi_1
X_1354_ VGND VPWR net81 daisychain\[48\] _0460_ net42 sg13g2_a21oi_1
X_1285_ _0733_ net120 _0407_ _0408_ VPWR VGND sg13g2_a21o_1
XFILLER_36_375 VPWR VGND sg13g2_decap_8
XFILLER_32_581 VPWR VGND sg13g2_fill_1
Xclkload7 clknet_leaf_1_clk clkload7/Y VPWR VGND sg13g2_inv_4
Xfanout200 net202 net200 VPWR VGND sg13g2_buf_1
Xfanout211 net213 net211 VPWR VGND sg13g2_buf_1
Xfanout222 net223 net222 VPWR VGND sg13g2_buf_1
XFILLER_11_721 VPWR VGND sg13g2_fill_1
XFILLER_15_526 VPWR VGND sg13g2_fill_2
XFILLER_15_537 VPWR VGND sg13g2_fill_2
XFILLER_24_41 VPWR VGND sg13g2_decap_8
XFILLER_42_301 VPWR VGND sg13g2_decap_8
XFILLER_42_378 VPWR VGND sg13g2_decap_8
XFILLER_43_868 VPWR VGND sg13g2_decap_8
XFILLER_10_253 VPWR VGND sg13g2_decap_8
XFILLER_40_84 VPWR VGND sg13g2_decap_8
XFILLER_6_235 VPWR VGND sg13g2_decap_8
XFILLER_2_452 VPWR VGND sg13g2_decap_8
XFILLER_49_60 VPWR VGND sg13g2_decap_8
Xdigitalen0.g\[3\].u.inv2 VPWR digitalen0.g\[3\].u.OUTP digitalen0.g\[3\].u.OUTN VGND
+ sg13g2_inv_1
XFILLER_1_56 VPWR VGND sg13g2_decap_8
XFILLER_45_161 VPWR VGND sg13g2_decap_8
XFILLER_46_651 VPWR VGND sg13g2_decap_8
X_1070_ VPWR _0739_ daisychain\[38\] VGND sg13g2_inv_1
XFILLER_42_890 VPWR VGND sg13g2_decap_8
X_1972_ net197 VGND VPWR _0304_ state\[48\] clknet_leaf_14_clk sg13g2_dfrbpq_1
X_0923_ VPWR _0035_ state\[16\] VGND sg13g2_inv_1
XFILLER_46_0 VPWR VGND sg13g2_decap_8
X_1406_ VGND VPWR net79 daisychain\[61\] _0499_ net36 sg13g2_a21oi_1
X_1337_ _0746_ net115 _0446_ _0447_ VPWR VGND sg13g2_a21o_1
X_1268_ net163 VPWR _0395_ VGND net121 state\[28\] sg13g2_o21ai_1
XFILLER_12_518 VPWR VGND sg13g2_decap_8
XFILLER_36_172 VPWR VGND sg13g2_decap_8
X_1199_ _0138_ _0856_ _0857_ net65 _0711_ VPWR VGND sg13g2_a22oi_1
XFILLER_20_551 VPWR VGND sg13g2_decap_4
XFILLER_4_739 VPWR VGND sg13g2_decap_8
XFILLER_10_43 VPWR VGND sg13g2_decap_8
XFILLER_19_30 VPWR VGND sg13g2_decap_8
XFILLER_3_249 VPWR VGND sg13g2_decap_8
XFILLER_19_128 VPWR VGND sg13g2_decap_8
XFILLER_34_109 VPWR VGND sg13g2_decap_8
XFILLER_47_448 VPWR VGND sg13g2_decap_8
XFILLER_31_827 VPWR VGND sg13g2_decap_8
XFILLER_35_95 VPWR VGND sg13g2_decap_8
XFILLER_42_175 VPWR VGND sg13g2_decap_8
XFILLER_43_665 VPWR VGND sg13g2_decap_8
XFILLER_7_544 VPWR VGND sg13g2_decap_4
XFILLER_7_599 VPWR VGND sg13g2_decap_8
XFILLER_39_916 VPWR VGND sg13g2_decap_8
X_1122_ VPWR _0791_ daisychain\[90\] VGND sg13g2_inv_1
XFILLER_33_186 VPWR VGND sg13g2_decap_8
XFILLER_34_610 VPWR VGND sg13g2_decap_8
X_1053_ VPWR _0722_ daisychain\[21\] VGND sg13g2_inv_1
X_1955_ net210 VGND VPWR _0287_ state\[31\] clknet_leaf_8_clk sg13g2_dfrbpq_1
X_1886_ net215 VGND VPWR _0218_ daisychain\[90\] clknet_leaf_5_clk sg13g2_dfrbpq_1
X_0906_ VPWR _0700_ daisychain\[127\] VGND sg13g2_inv_1
XFILLER_37_470 VPWR VGND sg13g2_fill_2
XFILLER_12_304 VPWR VGND sg13g2_decap_8
XFILLER_24_164 VPWR VGND sg13g2_decap_8
XFILLER_40_613 VPWR VGND sg13g2_decap_8
XFILLER_8_319 VPWR VGND sg13g2_decap_8
XFILLER_21_64 VPWR VGND sg13g2_decap_8
XFILLER_4_536 VPWR VGND sg13g2_decap_8
XFILLER_0_786 VPWR VGND sg13g2_decap_8
XFILLER_47_245 VPWR VGND sg13g2_decap_8
XFILLER_48_757 VPWR VGND sg13g2_decap_8
XFILLER_15_131 VPWR VGND sg13g2_decap_8
XFILLER_43_462 VPWR VGND sg13g2_decap_8
XFILLER_30_134 VPWR VGND sg13g2_decap_8
XFILLER_7_77 VPWR VGND sg13g2_decap_8
XFILLER_8_897 VPWR VGND sg13g2_decap_8
X_1740_ _0528_ VPWR _0328_ VGND net155 _0097_ sg13g2_o21ai_1
X_1671_ _0835_ VPWR _0259_ VGND net179 _0061_ sg13g2_o21ai_1
XFILLER_7_385 VPWR VGND sg13g2_decap_8
XFILLER_38_245 VPWR VGND sg13g2_decap_8
XFILLER_39_757 VPWR VGND sg13g2_fill_1
X_1105_ VPWR _0774_ daisychain\[73\] VGND sg13g2_inv_1
XFILLER_10_808 VPWR VGND sg13g2_decap_8
XFILLER_21_134 VPWR VGND sg13g2_decap_8
XFILLER_34_451 VPWR VGND sg13g2_decap_4
X_1036_ VPWR _0705_ daisychain\[4\] VGND sg13g2_inv_1
X_1938_ net222 VGND VPWR _0270_ state\[14\] clknet_leaf_9_clk sg13g2_dfrbpq_1
X_1869_ net199 VGND VPWR _0201_ daisychain\[73\] clknet_leaf_2_clk sg13g2_dfrbpq_1
XFILLER_18_908 VPWR VGND sg13g2_decap_8
XFILLER_12_101 VPWR VGND sg13g2_decap_8
XFILLER_16_53 VPWR VGND sg13g2_decap_4
XFILLER_44_259 VPWR VGND sg13g2_decap_8
XFILLER_45_749 VPWR VGND sg13g2_decap_8
XFILLER_12_178 VPWR VGND sg13g2_decap_8
XFILLER_13_679 VPWR VGND sg13g2_decap_8
XFILLER_32_74 VPWR VGND sg13g2_decap_8
XFILLER_40_421 VPWR VGND sg13g2_decap_8
XFILLER_5_823 VPWR VGND sg13g2_decap_8
XFILLER_8_116 VPWR VGND sg13g2_decap_8
XFILLER_4_333 VPWR VGND sg13g2_decap_8
XFILLER_36_738 VPWR VGND sg13g2_decap_8
XFILLER_48_532 VPWR VGND sg13g2_decap_8
XFILLER_31_443 VPWR VGND sg13g2_fill_1
XFILLER_32_922 VPWR VGND sg13g2_decap_4
XFILLER_44_771 VPWR VGND sg13g2_decap_8
XFILLER_7_182 VPWR VGND sg13g2_decap_8
X_1723_ _0477_ VPWR _0311_ VGND net152 _0078_ sg13g2_o21ai_1
X_1654_ VGND VPWR daisychain\[123\] net78 _0685_ net34 sg13g2_a21oi_1
X_1585_ _0808_ net139 _0632_ _0633_ VPWR VGND sg13g2_a21o_1
XFILLER_35_771 VPWR VGND sg13g2_decap_8
X_2068_ daisychain\[120\] net26 VPWR VGND sg13g2_buf_1
X_1019_ VPWR _0014_ state\[112\] VGND sg13g2_inv_1
XFILLER_1_336 VPWR VGND sg13g2_decap_8
XFILLER_2_837 VPWR VGND sg13g2_decap_8
XFILLER_17_237 VPWR VGND sg13g2_decap_8
XFILLER_18_705 VPWR VGND sg13g2_fill_2
XFILLER_45_546 VPWR VGND sg13g2_decap_8
XFILLER_14_900 VPWR VGND sg13g2_fill_1
XFILLER_32_207 VPWR VGND sg13g2_decap_8
XFILLER_41_730 VPWR VGND sg13g2_fill_2
XFILLER_40_273 VPWR VGND sg13g2_decap_8
XFILLER_43_84 VPWR VGND sg13g2_decap_8
XFILLER_4_130 VPWR VGND sg13g2_decap_8
XFILLER_5_620 VPWR VGND sg13g2_decap_8
XFILLER_9_436 VPWR VGND sg13g2_decap_8
XFILLER_4_67 VPWR VGND sg13g2_decap_8
XFILLER_5_697 VPWR VGND sg13g2_decap_8
X_1370_ VGND VPWR net80 daisychain\[52\] _0472_ net40 sg13g2_a21oi_1
XFILLER_49_863 VPWR VGND sg13g2_decap_8
XFILLER_32_741 VPWR VGND sg13g2_decap_8
XFILLER_32_752 VPWR VGND sg13g2_fill_1
X_1706_ _0426_ VPWR _0294_ VGND net162 _0059_ sg13g2_o21ai_1
X_1637_ _0821_ net144 _0671_ _0672_ VPWR VGND sg13g2_a21o_1
X_1568_ net184 VPWR _0620_ VGND net141 state\[103\] sg13g2_o21ai_1
X_1499_ _0213_ _0567_ _0568_ net56 _0786_ VPWR VGND sg13g2_a22oi_1
XFILLER_14_229 VPWR VGND sg13g2_decap_8
Xfanout55 net63 net55 VPWR VGND sg13g2_buf_1
Xfanout44 net48 net44 VPWR VGND sg13g2_buf_1
XFILLER_10_468 VPWR VGND sg13g2_fill_1
XFILLER_6_417 VPWR VGND sg13g2_decap_8
Xfanout99 _0696_ net99 VPWR VGND sg13g2_buf_1
Xfanout88 net89 net88 VPWR VGND sg13g2_buf_1
Xfanout77 _0826_ net77 VPWR VGND sg13g2_buf_1
Xfanout66 net70 net66 VPWR VGND sg13g2_buf_1
XFILLER_1_133 VPWR VGND sg13g2_decap_8
XFILLER_2_634 VPWR VGND sg13g2_decap_8
XFILLER_49_137 VPWR VGND sg13g2_decap_8
XFILLER_38_84 VPWR VGND sg13g2_decap_8
XFILLER_45_343 VPWR VGND sg13g2_decap_8
XFILLER_46_833 VPWR VGND sg13g2_decap_8
XFILLER_13_240 VPWR VGND sg13g2_decap_8
XFILLER_41_593 VPWR VGND sg13g2_decap_8
XFILLER_9_200 VPWR VGND sg13g2_decap_8
XFILLER_9_277 VPWR VGND sg13g2_decap_8
XFILLER_5_494 VPWR VGND sg13g2_decap_8
X_1422_ VGND VPWR net79 daisychain\[65\] _0511_ net37 sg13g2_a21oi_1
X_1353_ _0750_ net107 _0458_ _0459_ VPWR VGND sg13g2_a21o_1
X_1284_ net165 VPWR _0407_ VGND net120 state\[32\] sg13g2_o21ai_1
XFILLER_20_766 VPWR VGND sg13g2_fill_1
Xclkload8 clkload8/Y clknet_leaf_8_clk VPWR VGND sg13g2_inv_8
X_0999_ VPWR _0119_ state\[92\] VGND sg13g2_inv_1
Xfanout201 net202 net201 VPWR VGND sg13g2_buf_1
Xfanout212 net213 net212 VPWR VGND sg13g2_buf_1
Xfanout223 net224 net223 VPWR VGND sg13g2_buf_1
XFILLER_10_232 VPWR VGND sg13g2_decap_8
XFILLER_24_20 VPWR VGND sg13g2_decap_8
XFILLER_42_357 VPWR VGND sg13g2_decap_8
XFILLER_43_847 VPWR VGND sg13g2_decap_8
XFILLER_2_431 VPWR VGND sg13g2_decap_8
XFILLER_3_921 VPWR VGND sg13g2_decap_4
XFILLER_40_63 VPWR VGND sg13g2_decap_8
XFILLER_6_214 VPWR VGND sg13g2_decap_8
XFILLER_1_35 VPWR VGND sg13g2_decap_8
XFILLER_18_343 VPWR VGND sg13g2_decap_4
XFILLER_19_888 VPWR VGND sg13g2_fill_1
XFILLER_34_847 VPWR VGND sg13g2_fill_2
XFILLER_45_140 VPWR VGND sg13g2_decap_8
XFILLER_46_630 VPWR VGND sg13g2_decap_8
X_1971_ net210 VGND VPWR _0303_ state\[47\] clknet_leaf_14_clk sg13g2_dfrbpq_1
X_0922_ VPWR _0034_ state\[15\] VGND sg13g2_inv_1
XFILLER_39_0 VPWR VGND sg13g2_decap_8
XFILLER_5_291 VPWR VGND sg13g2_decap_8
X_1405_ _0763_ net102 _0497_ _0498_ VPWR VGND sg13g2_a21o_1
XFILLER_36_151 VPWR VGND sg13g2_decap_8
XFILLER_37_663 VPWR VGND sg13g2_fill_2
Xinput1 rst_n net1 VPWR VGND sg13g2_buf_1
X_1336_ net160 VPWR _0446_ VGND net115 state\[45\] sg13g2_o21ai_1
X_1267_ _0155_ _0393_ _0394_ net52 _0728_ VPWR VGND sg13g2_a22oi_1
X_1198_ VGND VPWR net92 daisychain\[9\] _0857_ net64 sg13g2_a21oi_1
XFILLER_10_22 VPWR VGND sg13g2_decap_8
XFILLER_3_228 VPWR VGND sg13g2_decap_8
XFILLER_4_718 VPWR VGND sg13g2_decap_8
XFILLER_10_99 VPWR VGND sg13g2_decap_8
XFILLER_19_107 VPWR VGND sg13g2_decap_8
XFILLER_47_427 VPWR VGND sg13g2_decap_8
XFILLER_19_86 VPWR VGND sg13g2_decap_8
XFILLER_27_184 VPWR VGND sg13g2_decap_4
XFILLER_35_74 VPWR VGND sg13g2_decap_8
XFILLER_42_154 VPWR VGND sg13g2_decap_8
XFILLER_43_644 VPWR VGND sg13g2_decap_8
XFILLER_11_552 VPWR VGND sg13g2_decap_4
XFILLER_30_327 VPWR VGND sg13g2_fill_2
XFILLER_7_501 VPWR VGND sg13g2_fill_2
XFILLER_7_523 VPWR VGND sg13g2_decap_8
XFILLER_7_567 VPWR VGND sg13g2_fill_1
XFILLER_3_795 VPWR VGND sg13g2_decap_8
XFILLER_7_578 VPWR VGND sg13g2_decap_8
XFILLER_38_405 VPWR VGND sg13g2_fill_1
X_1121_ VPWR _0790_ daisychain\[89\] VGND sg13g2_inv_1
X_1052_ VPWR _0721_ daisychain\[20\] VGND sg13g2_inv_1
XFILLER_15_880 VPWR VGND sg13g2_decap_8
XFILLER_18_195 VPWR VGND sg13g2_decap_8
XFILLER_33_165 VPWR VGND sg13g2_decap_8
X_1954_ net209 VGND VPWR _0286_ state\[30\] clknet_leaf_8_clk sg13g2_dfrbpq_1
X_1885_ net212 VGND VPWR _0217_ daisychain\[89\] clknet_leaf_5_clk sg13g2_dfrbpq_1
X_0905_ VPWR _0030_ state\[127\] VGND sg13g2_inv_1
XFILLER_24_143 VPWR VGND sg13g2_decap_8
X_1319_ _0168_ _0432_ _0433_ net51 _0741_ VPWR VGND sg13g2_a22oi_1
XFILLER_21_43 VPWR VGND sg13g2_decap_8
XFILLER_4_515 VPWR VGND sg13g2_decap_8
XFILLER_0_765 VPWR VGND sg13g2_decap_8
XFILLER_47_224 VPWR VGND sg13g2_decap_8
XFILLER_48_714 VPWR VGND sg13g2_decap_8
XFILLER_15_110 VPWR VGND sg13g2_decap_8
XFILLER_15_187 VPWR VGND sg13g2_decap_8
XFILLER_30_113 VPWR VGND sg13g2_decap_8
XFILLER_31_669 VPWR VGND sg13g2_fill_1
XFILLER_43_441 VPWR VGND sg13g2_decap_8
XFILLER_46_84 VPWR VGND sg13g2_decap_8
XFILLER_11_393 VPWR VGND sg13g2_decap_4
XFILLER_12_872 VPWR VGND sg13g2_decap_8
XFILLER_7_364 VPWR VGND sg13g2_decap_8
XFILLER_7_56 VPWR VGND sg13g2_decap_8
XFILLER_8_832 VPWR VGND sg13g2_decap_8
XFILLER_8_843 VPWR VGND sg13g2_fill_2
XFILLER_8_854 VPWR VGND sg13g2_fill_1
XFILLER_8_887 VPWR VGND sg13g2_decap_4
X_1670_ _0832_ VPWR _0258_ VGND net181 _0050_ sg13g2_o21ai_1
XFILLER_30_4 VPWR VGND sg13g2_decap_4
XFILLER_3_592 VPWR VGND sg13g2_decap_8
XFILLER_19_471 VPWR VGND sg13g2_fill_2
XFILLER_19_482 VPWR VGND sg13g2_fill_2
XFILLER_35_920 VPWR VGND sg13g2_decap_8
XFILLER_38_224 VPWR VGND sg13g2_decap_8
XFILLER_47_791 VPWR VGND sg13g2_decap_8
X_1104_ VPWR _0773_ daisychain\[72\] VGND sg13g2_inv_1
X_1035_ VPWR _0704_ daisychain\[3\] VGND sg13g2_inv_1
XFILLER_21_113 VPWR VGND sg13g2_decap_8
X_1937_ net222 VGND VPWR _0269_ state\[13\] clknet_leaf_9_clk sg13g2_dfrbpq_1
XFILLER_1_529 VPWR VGND sg13g2_decap_8
X_1868_ net199 VGND VPWR _0200_ daisychain\[72\] clknet_leaf_2_clk sg13g2_dfrbpq_1
X_1799_ net220 VGND VPWR _0131_ daisychain\[3\] clknet_leaf_10_clk sg13g2_dfrbpq_1
XFILLER_29_202 VPWR VGND sg13g2_decap_8
XFILLER_45_728 VPWR VGND sg13g2_decap_8
XFILLER_16_98 VPWR VGND sg13g2_decap_8
XFILLER_40_400 VPWR VGND sg13g2_fill_2
XFILLER_44_238 VPWR VGND sg13g2_decap_8
XFILLER_12_157 VPWR VGND sg13g2_decap_8
XFILLER_32_53 VPWR VGND sg13g2_decap_8
XFILLER_4_312 VPWR VGND sg13g2_decap_8
XFILLER_5_802 VPWR VGND sg13g2_decap_8
XFILLER_48_511 VPWR VGND sg13g2_decap_8
XFILLER_4_389 VPWR VGND sg13g2_decap_8
XFILLER_5_879 VPWR VGND sg13g2_decap_8
XFILLER_35_249 VPWR VGND sg13g2_decap_8
XFILLER_44_750 VPWR VGND sg13g2_decap_8
XFILLER_48_588 VPWR VGND sg13g2_decap_8
XFILLER_7_161 VPWR VGND sg13g2_decap_8
XFILLER_8_695 VPWR VGND sg13g2_fill_2
X_1722_ _0474_ VPWR _0310_ VGND net150 _0077_ sg13g2_o21ai_1
X_1653_ _0698_ net100 _0683_ _0684_ VPWR VGND sg13g2_a21o_1
X_1584_ net183 VPWR _0632_ VGND net139 state\[107\] sg13g2_o21ai_1
XFILLER_39_577 VPWR VGND sg13g2_decap_4
X_2067_ state\[127\] net25 VPWR VGND sg13g2_buf_1
X_1018_ VPWR _0013_ state\[111\] VGND sg13g2_inv_1
XFILLER_10_639 VPWR VGND sg13g2_decap_8
XFILLER_5_109 VPWR VGND sg13g2_decap_8
XFILLER_1_315 VPWR VGND sg13g2_decap_8
XFILLER_2_816 VPWR VGND sg13g2_decap_8
XFILLER_49_319 VPWR VGND sg13g2_decap_8
XFILLER_17_216 VPWR VGND sg13g2_decap_8
XFILLER_27_20 VPWR VGND sg13g2_decap_4
XFILLER_27_86 VPWR VGND sg13g2_decap_8
XFILLER_45_525 VPWR VGND sg13g2_decap_8
XFILLER_14_923 VPWR VGND sg13g2_decap_4
XFILLER_40_252 VPWR VGND sg13g2_decap_8
XFILLER_43_63 VPWR VGND sg13g2_decap_8
XFILLER_9_415 VPWR VGND sg13g2_decap_8
XFILLER_5_676 VPWR VGND sg13g2_decap_8
XFILLER_0_392 VPWR VGND sg13g2_decap_8
XFILLER_1_893 VPWR VGND sg13g2_decap_8
XFILLER_49_842 VPWR VGND sg13g2_decap_8
XFILLER_4_186 VPWR VGND sg13g2_decap_8
XFILLER_4_46 VPWR VGND sg13g2_decap_8
XFILLER_17_783 VPWR VGND sg13g2_fill_1
XFILLER_48_385 VPWR VGND sg13g2_decap_8
XFILLER_31_285 VPWR VGND sg13g2_decap_4
XFILLER_8_470 VPWR VGND sg13g2_fill_2
X_1705_ _0423_ VPWR _0293_ VGND net159 _0058_ sg13g2_o21ai_1
X_1636_ net187 VPWR _0671_ VGND net144 state\[120\] sg13g2_o21ai_1
X_1567_ _0230_ _0618_ _0619_ net60 _0803_ VPWR VGND sg13g2_a22oi_1
X_1498_ VGND VPWR net84 daisychain\[84\] _0568_ net56 sg13g2_a21oi_1
XFILLER_11_926 VPWR VGND sg13g2_fill_1
XFILLER_14_208 VPWR VGND sg13g2_decap_8
XFILLER_35_580 VPWR VGND sg13g2_fill_1
Xfanout34 net35 net34 VPWR VGND sg13g2_buf_1
Xfanout89 net91 net89 VPWR VGND sg13g2_buf_1
Xfanout78 net79 net78 VPWR VGND sg13g2_buf_1
Xfanout67 net68 net67 VPWR VGND sg13g2_buf_1
Xfanout56 net57 net56 VPWR VGND sg13g2_buf_1
Xfanout45 net47 net45 VPWR VGND sg13g2_buf_1
XFILLER_10_447 VPWR VGND sg13g2_decap_8
XFILLER_2_613 VPWR VGND sg13g2_decap_8
XFILLER_1_112 VPWR VGND sg13g2_decap_8
XFILLER_1_189 VPWR VGND sg13g2_decap_8
XFILLER_38_63 VPWR VGND sg13g2_decap_8
XFILLER_49_116 VPWR VGND sg13g2_decap_8
XFILLER_8_4 VPWR VGND sg13g2_decap_8
XFILLER_18_558 VPWR VGND sg13g2_fill_2
XFILLER_45_322 VPWR VGND sg13g2_decap_8
XFILLER_45_399 VPWR VGND sg13g2_decap_8
XFILLER_46_812 VPWR VGND sg13g2_decap_8
XFILLER_46_889 VPWR VGND sg13g2_decap_8
XFILLER_9_256 VPWR VGND sg13g2_decap_8
XFILLER_5_473 VPWR VGND sg13g2_decap_8
X_1421_ _0767_ net103 _0509_ _0510_ VPWR VGND sg13g2_a21o_1
XFILLER_1_690 VPWR VGND sg13g2_decap_8
XFILLER_48_182 VPWR VGND sg13g2_decap_8
XFILLER_49_694 VPWR VGND sg13g2_decap_8
X_1352_ net151 VPWR _0458_ VGND net107 state\[49\] sg13g2_o21ai_1
X_1283_ _0159_ _0405_ _0406_ net55 _0732_ VPWR VGND sg13g2_a22oi_1
Xclkload9 clknet_leaf_9_clk clkload9/X VPWR VGND sg13g2_buf_8
X_0998_ VPWR _0118_ state\[91\] VGND sg13g2_inv_1
XFILLER_47_609 VPWR VGND sg13g2_decap_8
Xfanout202 net203 net202 VPWR VGND sg13g2_buf_1
Xfanout213 net231 net213 VPWR VGND sg13g2_buf_1
Xfanout224 net231 net224 VPWR VGND sg13g2_buf_1
X_1619_ _0243_ _0657_ _0658_ net74 _0816_ VPWR VGND sg13g2_a22oi_1
XFILLER_15_539 VPWR VGND sg13g2_fill_1
XFILLER_39_182 VPWR VGND sg13g2_decap_8
XFILLER_42_336 VPWR VGND sg13g2_decap_8
XFILLER_43_826 VPWR VGND sg13g2_decap_8
XFILLER_46_119 VPWR VGND sg13g2_decap_8
XFILLER_10_211 VPWR VGND sg13g2_decap_8
XFILLER_11_789 VPWR VGND sg13g2_fill_1
XFILLER_24_87 VPWR VGND sg13g2_decap_8
XFILLER_7_716 VPWR VGND sg13g2_fill_2
XFILLER_10_288 VPWR VGND sg13g2_decap_8
XFILLER_2_410 VPWR VGND sg13g2_decap_8
XFILLER_3_900 VPWR VGND sg13g2_decap_8
XFILLER_40_42 VPWR VGND sg13g2_decap_8
XFILLER_18_300 VPWR VGND sg13g2_fill_2
XFILLER_1_14 VPWR VGND sg13g2_decap_8
XFILLER_2_487 VPWR VGND sg13g2_decap_8
XFILLER_37_119 VPWR VGND sg13g2_decap_8
XFILLER_49_95 VPWR VGND sg13g2_decap_8
XFILLER_45_196 VPWR VGND sg13g2_decap_8
XFILLER_46_686 VPWR VGND sg13g2_decap_8
X_1970_ net206 VGND VPWR _0302_ state\[46\] clknet_leaf_13_clk sg13g2_dfrbpq_1
X_0921_ VPWR _0033_ state\[14\] VGND sg13g2_inv_1
XFILLER_5_270 VPWR VGND sg13g2_decap_8
X_1404_ net147 VPWR _0497_ VGND net102 state\[62\] sg13g2_o21ai_1
X_1335_ _0172_ _0444_ _0445_ net49 _0745_ VPWR VGND sg13g2_a22oi_1
XFILLER_28_119 VPWR VGND sg13g2_decap_8
XFILLER_36_130 VPWR VGND sg13g2_decap_8
XFILLER_37_686 VPWR VGND sg13g2_fill_2
Xinput2 ui_in[0] net2 VPWR VGND sg13g2_buf_1
X_1266_ VGND VPWR net85 daisychain\[26\] _0394_ net52 sg13g2_a21oi_1
X_1197_ _0711_ net134 _0855_ _0856_ VPWR VGND sg13g2_a21o_1
XFILLER_12_509 VPWR VGND sg13g2_fill_1
XFILLER_33_892 VPWR VGND sg13g2_fill_1
XFILLER_10_78 VPWR VGND sg13g2_decap_8
XFILLER_3_207 VPWR VGND sg13g2_decap_8
XFILLER_0_925 VPWR VGND sg13g2_fill_2
XFILLER_19_65 VPWR VGND sg13g2_decap_8
XFILLER_47_406 VPWR VGND sg13g2_decap_8
XFILLER_48_918 VPWR VGND sg13g2_decap_8
XFILLER_27_163 VPWR VGND sg13g2_decap_8
XFILLER_35_53 VPWR VGND sg13g2_decap_8
XFILLER_42_133 VPWR VGND sg13g2_decap_8
XFILLER_43_623 VPWR VGND sg13g2_decap_8
XFILLER_2_284 VPWR VGND sg13g2_decap_8
XFILLER_3_774 VPWR VGND sg13g2_decap_8
XFILLER_18_174 VPWR VGND sg13g2_decap_8
XFILLER_46_483 VPWR VGND sg13g2_decap_8
X_1120_ VPWR _0789_ daisychain\[88\] VGND sg13g2_inv_1
X_1051_ VPWR _0720_ daisychain\[19\] VGND sg13g2_inv_1
XFILLER_33_144 VPWR VGND sg13g2_decap_8
X_1953_ net209 VGND VPWR _0285_ state\[29\] clknet_leaf_8_clk sg13g2_dfrbpq_1
X_1884_ net211 VGND VPWR _0216_ daisychain\[88\] clknet_leaf_4_clk sg13g2_dfrbpq_1
X_0904_ VPWR _0699_ daisychain\[126\] VGND sg13g2_inv_1
X_1318_ VGND VPWR net87 daisychain\[39\] _0433_ net51 sg13g2_a21oi_1
XFILLER_13_829 VPWR VGND sg13g2_decap_8
XFILLER_24_122 VPWR VGND sg13g2_decap_8
X_1249_ _0724_ net130 _0894_ _0895_ VPWR VGND sg13g2_a21o_1
XFILLER_12_339 VPWR VGND sg13g2_decap_8
XFILLER_21_22 VPWR VGND sg13g2_decap_8
XFILLER_24_199 VPWR VGND sg13g2_decap_8
XFILLER_0_744 VPWR VGND sg13g2_decap_8
XFILLER_21_99 VPWR VGND sg13g2_decap_8
XFILLER_46_63 VPWR VGND sg13g2_decap_8
XFILLER_47_203 VPWR VGND sg13g2_decap_8
XFILLER_15_166 VPWR VGND sg13g2_decap_8
XFILLER_30_169 VPWR VGND sg13g2_decap_8
XFILLER_31_626 VPWR VGND sg13g2_fill_2
XFILLER_43_420 VPWR VGND sg13g2_decap_8
XFILLER_43_497 VPWR VGND sg13g2_decap_8
XFILLER_8_822 VPWR VGND sg13g2_decap_8
XFILLER_7_343 VPWR VGND sg13g2_decap_8
XFILLER_7_35 VPWR VGND sg13g2_decap_8
XFILLER_23_4 VPWR VGND sg13g2_decap_4
XFILLER_38_203 VPWR VGND sg13g2_decap_8
XFILLER_3_571 VPWR VGND sg13g2_decap_8
XFILLER_34_431 VPWR VGND sg13g2_decap_8
XFILLER_46_280 VPWR VGND sg13g2_decap_8
XFILLER_47_770 VPWR VGND sg13g2_decap_8
X_1103_ VPWR _0772_ daisychain\[71\] VGND sg13g2_inv_1
X_1034_ VPWR _0703_ daisychain\[2\] VGND sg13g2_inv_1
XFILLER_21_169 VPWR VGND sg13g2_decap_8
X_1936_ net221 VGND VPWR _0268_ state\[12\] clknet_leaf_10_clk sg13g2_dfrbpq_1
X_1867_ net202 VGND VPWR _0199_ daisychain\[71\] clknet_leaf_3_clk sg13g2_dfrbpq_1
XFILLER_1_508 VPWR VGND sg13g2_decap_8
X_1798_ net220 VGND VPWR _0130_ daisychain\[2\] clknet_leaf_10_clk sg13g2_dfrbpq_1
XFILLER_17_409 VPWR VGND sg13g2_fill_2
XFILLER_38_781 VPWR VGND sg13g2_decap_8
XFILLER_44_217 VPWR VGND sg13g2_decap_8
XFILLER_45_707 VPWR VGND sg13g2_decap_8
XFILLER_12_136 VPWR VGND sg13g2_decap_8
XFILLER_16_77 VPWR VGND sg13g2_decap_8
XFILLER_37_280 VPWR VGND sg13g2_decap_8
XFILLER_40_456 VPWR VGND sg13g2_decap_8
XFILLER_41_913 VPWR VGND sg13g2_decap_8
XFILLER_32_32 VPWR VGND sg13g2_decap_8
XFILLER_5_858 VPWR VGND sg13g2_decap_8
XFILLER_0_596 VPWR VGND sg13g2_decap_8
XFILLER_4_368 VPWR VGND sg13g2_decap_8
XFILLER_35_228 VPWR VGND sg13g2_decap_8
XFILLER_48_567 VPWR VGND sg13g2_decap_8
XFILLER_11_191 VPWR VGND sg13g2_decap_8
XFILLER_12_670 VPWR VGND sg13g2_decap_8
XFILLER_16_497 VPWR VGND sg13g2_decap_8
XFILLER_31_412 VPWR VGND sg13g2_decap_8
XFILLER_31_434 VPWR VGND sg13g2_fill_2
XFILLER_31_478 VPWR VGND sg13g2_fill_1
XFILLER_43_294 VPWR VGND sg13g2_decap_8
XFILLER_7_140 VPWR VGND sg13g2_decap_8
X_1721_ _0471_ VPWR _0309_ VGND net150 _0076_ sg13g2_o21ai_1
X_1652_ net146 VPWR _0683_ VGND net100 state\[124\] sg13g2_o21ai_1
X_1583_ _0234_ _0630_ _0631_ net72 _0807_ VPWR VGND sg13g2_a22oi_1
XFILLER_26_217 VPWR VGND sg13g2_decap_4
XFILLER_34_283 VPWR VGND sg13g2_decap_4
X_2066_ state\[126\] net24 VPWR VGND sg13g2_buf_1
X_1017_ VPWR _0012_ state\[110\] VGND sg13g2_inv_1
X_1919_ net190 VGND VPWR _0251_ daisychain\[123\] clknet_leaf_0_clk sg13g2_dfrbpq_1
XFILLER_45_504 VPWR VGND sg13g2_decap_8
XFILLER_40_231 VPWR VGND sg13g2_decap_8
XFILLER_41_787 VPWR VGND sg13g2_decap_8
XFILLER_43_42 VPWR VGND sg13g2_decap_8
XFILLER_4_165 VPWR VGND sg13g2_decap_8
XFILLER_4_25 VPWR VGND sg13g2_decap_8
XFILLER_5_655 VPWR VGND sg13g2_decap_8
XFILLER_0_371 VPWR VGND sg13g2_decap_8
XFILLER_1_872 VPWR VGND sg13g2_decap_8
XFILLER_48_364 VPWR VGND sg13g2_decap_8
XFILLER_49_898 VPWR VGND sg13g2_decap_8
XFILLER_44_581 VPWR VGND sg13g2_decap_8
X_1704_ _0420_ VPWR _0292_ VGND net159 _0057_ sg13g2_o21ai_1
X_1635_ _0247_ _0669_ _0670_ net76 _0820_ VPWR VGND sg13g2_a22oi_1
X_1566_ VGND VPWR net89 daisychain\[101\] _0619_ net60 sg13g2_a21oi_1
X_1497_ _0786_ net124 _0566_ _0567_ VPWR VGND sg13g2_a21o_1
X_2049_ net229 VGND VPWR _0381_ state\[125\] clknet_leaf_8_clk sg13g2_dfrbpq_1
Xfanout35 net36 net35 VPWR VGND sg13g2_buf_1
Xfanout79 net99 net79 VPWR VGND sg13g2_buf_1
Xfanout68 net69 net68 VPWR VGND sg13g2_buf_1
Xfanout57 net58 net57 VPWR VGND sg13g2_buf_1
Xfanout46 net47 net46 VPWR VGND sg13g2_buf_1
XFILLER_1_168 VPWR VGND sg13g2_decap_8
XFILLER_2_669 VPWR VGND sg13g2_decap_8
XFILLER_38_42 VPWR VGND sg13g2_decap_8
XFILLER_45_301 VPWR VGND sg13g2_decap_8
XFILLER_41_551 VPWR VGND sg13g2_fill_2
XFILLER_45_378 VPWR VGND sg13g2_decap_8
XFILLER_46_868 VPWR VGND sg13g2_decap_8
XFILLER_13_275 VPWR VGND sg13g2_decap_8
XFILLER_9_235 VPWR VGND sg13g2_decap_8
XFILLER_5_452 VPWR VGND sg13g2_decap_8
X_1420_ net153 VPWR _0509_ VGND net103 state\[66\] sg13g2_o21ai_1
X_1351_ _0176_ _0456_ _0457_ net42 _0749_ VPWR VGND sg13g2_a22oi_1
XFILLER_36_312 VPWR VGND sg13g2_decap_8
XFILLER_36_367 VPWR VGND sg13g2_fill_2
XFILLER_48_161 VPWR VGND sg13g2_decap_8
XFILLER_49_673 VPWR VGND sg13g2_decap_8
X_1282_ VGND VPWR net86 daisychain\[30\] _0406_ net55 sg13g2_a21oi_1
XFILLER_20_702 VPWR VGND sg13g2_fill_1
XFILLER_20_757 VPWR VGND sg13g2_decap_8
XFILLER_36_389 VPWR VGND sg13g2_fill_2
X_1618_ VGND VPWR net97 daisychain\[114\] _0658_ net74 sg13g2_a21oi_1
X_0997_ VPWR _0117_ state\[90\] VGND sg13g2_inv_1
XFILLER_39_161 VPWR VGND sg13g2_decap_8
Xfanout203 net1 net203 VPWR VGND sg13g2_buf_1
Xfanout214 net215 net214 VPWR VGND sg13g2_buf_1
Xfanout225 net226 net225 VPWR VGND sg13g2_buf_1
X_1549_ _0799_ net126 _0605_ _0606_ VPWR VGND sg13g2_a21o_1
XFILLER_36_890 VPWR VGND sg13g2_decap_8
XFILLER_42_315 VPWR VGND sg13g2_decap_8
XFILLER_43_805 VPWR VGND sg13g2_decap_8
XFILLER_10_267 VPWR VGND sg13g2_decap_8
XFILLER_11_779 VPWR VGND sg13g2_decap_8
XFILLER_40_21 VPWR VGND sg13g2_decap_8
XFILLER_6_249 VPWR VGND sg13g2_decap_8
XFILLER_2_466 VPWR VGND sg13g2_decap_8
XFILLER_40_98 VPWR VGND sg13g2_decap_8
XFILLER_18_356 VPWR VGND sg13g2_fill_2
XFILLER_19_879 VPWR VGND sg13g2_decap_8
XFILLER_46_665 VPWR VGND sg13g2_decap_8
XFILLER_49_74 VPWR VGND sg13g2_decap_8
XFILLER_18_378 VPWR VGND sg13g2_decap_8
XFILLER_33_304 VPWR VGND sg13g2_fill_1
XFILLER_41_381 VPWR VGND sg13g2_fill_1
XFILLER_45_175 VPWR VGND sg13g2_decap_8
X_0920_ VPWR _0032_ state\[13\] VGND sg13g2_inv_1
XFILLER_6_783 VPWR VGND sg13g2_decap_8
X_1403_ _0189_ _0495_ _0496_ net36 _0762_ VPWR VGND sg13g2_a22oi_1
X_1334_ VGND VPWR net87 daisychain\[43\] _0445_ net49 sg13g2_a21oi_1
X_1265_ _0728_ net118 _0392_ _0393_ VPWR VGND sg13g2_a21o_1
XFILLER_36_186 VPWR VGND sg13g2_decap_8
XFILLER_49_492 VPWR VGND sg13g2_decap_8
Xinput3 ui_in[1] net3 VPWR VGND sg13g2_buf_1
X_1196_ net177 VPWR _0855_ VGND net134 state\[10\] sg13g2_o21ai_1
XFILLER_20_598 VPWR VGND sg13g2_decap_8
XFILLER_33_871 VPWR VGND sg13g2_decap_8
XFILLER_33_882 VPWR VGND sg13g2_fill_1
XFILLER_0_904 VPWR VGND sg13g2_decap_8
XFILLER_10_57 VPWR VGND sg13g2_decap_8
XFILLER_19_44 VPWR VGND sg13g2_decap_8
XFILLER_27_142 VPWR VGND sg13g2_decap_8
XFILLER_43_602 VPWR VGND sg13g2_decap_8
XFILLER_16_827 VPWR VGND sg13g2_decap_4
XFILLER_30_307 VPWR VGND sg13g2_fill_1
XFILLER_30_318 VPWR VGND sg13g2_decap_4
XFILLER_35_32 VPWR VGND sg13g2_decap_8
XFILLER_42_112 VPWR VGND sg13g2_decap_8
XFILLER_42_189 VPWR VGND sg13g2_decap_8
XFILLER_43_679 VPWR VGND sg13g2_decap_8
XFILLER_25_8 VPWR VGND sg13g2_fill_1
XFILLER_2_263 VPWR VGND sg13g2_decap_8
XFILLER_38_429 VPWR VGND sg13g2_decap_8
XFILLER_3_753 VPWR VGND sg13g2_decap_8
XFILLER_18_153 VPWR VGND sg13g2_decap_8
XFILLER_19_632 VPWR VGND sg13g2_decap_8
XFILLER_33_123 VPWR VGND sg13g2_decap_8
XFILLER_34_668 VPWR VGND sg13g2_fill_2
XFILLER_46_462 VPWR VGND sg13g2_decap_8
X_1050_ VPWR _0719_ daisychain\[18\] VGND sg13g2_inv_1
XFILLER_14_392 VPWR VGND sg13g2_fill_1
XFILLER_15_893 VPWR VGND sg13g2_fill_2
XFILLER_30_830 VPWR VGND sg13g2_decap_8
XFILLER_30_852 VPWR VGND sg13g2_fill_1
X_1952_ net208 VGND VPWR _0284_ state\[28\] clknet_leaf_11_clk sg13g2_dfrbpq_1
X_1883_ net211 VGND VPWR _0215_ daisychain\[87\] clknet_leaf_4_clk sg13g2_dfrbpq_1
X_0903_ VPWR _0029_ state\[126\] VGND sg13g2_inv_1
XFILLER_44_0 VPWR VGND sg13g2_decap_8
X_1317_ _0741_ net117 _0431_ _0432_ VPWR VGND sg13g2_a21o_1
X_1248_ net174 VPWR _0894_ VGND net130 state\[23\] sg13g2_o21ai_1
XFILLER_12_318 VPWR VGND sg13g2_decap_8
XFILLER_24_101 VPWR VGND sg13g2_decap_8
XFILLER_24_178 VPWR VGND sg13g2_decap_8
XFILLER_37_462 VPWR VGND sg13g2_decap_4
X_1179_ _0133_ _0841_ _0842_ net67 _0706_ VPWR VGND sg13g2_a22oi_1
XFILLER_20_373 VPWR VGND sg13g2_decap_8
XFILLER_21_78 VPWR VGND sg13g2_decap_8
XFILLER_0_701 VPWR VGND sg13g2_fill_2
XFILLER_0_723 VPWR VGND sg13g2_decap_8
XFILLER_16_646 VPWR VGND sg13g2_decap_8
XFILLER_44_911 VPWR VGND sg13g2_decap_8
XFILLER_46_42 VPWR VGND sg13g2_decap_8
XFILLER_47_259 VPWR VGND sg13g2_decap_8
XFILLER_15_145 VPWR VGND sg13g2_decap_8
XFILLER_30_148 VPWR VGND sg13g2_decap_8
XFILLER_43_476 VPWR VGND sg13g2_decap_8
XFILLER_7_14 VPWR VGND sg13g2_decap_8
XFILLER_7_322 VPWR VGND sg13g2_decap_8
XFILLER_3_550 VPWR VGND sg13g2_decap_8
XFILLER_7_399 VPWR VGND sg13g2_decap_8
XFILLER_38_259 VPWR VGND sg13g2_decap_8
X_1102_ VPWR _0771_ daisychain\[70\] VGND sg13g2_inv_1
XFILLER_19_484 VPWR VGND sg13g2_fill_1
XFILLER_19_495 VPWR VGND sg13g2_decap_8
XFILLER_34_487 VPWR VGND sg13g2_fill_2
X_1033_ VPWR _0702_ daisychain\[1\] VGND sg13g2_inv_1
XFILLER_21_148 VPWR VGND sg13g2_decap_8
X_1935_ net218 VGND VPWR _0267_ state\[11\] clknet_leaf_9_clk sg13g2_dfrbpq_1
X_1866_ net198 VGND VPWR _0198_ daisychain\[70\] clknet_leaf_3_clk sg13g2_dfrbpq_1
X_1797_ net222 VGND VPWR _0129_ daisychain\[1\] clknet_leaf_9_clk sg13g2_dfrbpq_1
XFILLER_12_115 VPWR VGND sg13g2_decap_8
XFILLER_13_605 VPWR VGND sg13g2_decap_8
XFILLER_32_11 VPWR VGND sg13g2_decap_8
XFILLER_40_402 VPWR VGND sg13g2_fill_1
XFILLER_40_435 VPWR VGND sg13g2_decap_8
XFILLER_9_609 VPWR VGND sg13g2_decap_8
XFILLER_20_181 VPWR VGND sg13g2_decap_8
XFILLER_32_88 VPWR VGND sg13g2_decap_8
XFILLER_4_347 VPWR VGND sg13g2_decap_8
XFILLER_5_837 VPWR VGND sg13g2_decap_8
XFILLER_48_546 VPWR VGND sg13g2_decap_8
XFILLER_16_432 VPWR VGND sg13g2_decap_4
XFILLER_28_281 VPWR VGND sg13g2_fill_2
XFILLER_31_402 VPWR VGND sg13g2_fill_1
XFILLER_35_207 VPWR VGND sg13g2_decap_8
XFILLER_43_273 VPWR VGND sg13g2_decap_8
XFILLER_44_785 VPWR VGND sg13g2_decap_8
XFILLER_11_170 VPWR VGND sg13g2_decap_8
XFILLER_8_642 VPWR VGND sg13g2_fill_2
X_1720_ _0468_ VPWR _0308_ VGND net150 _0075_ sg13g2_o21ai_1
X_1651_ _0251_ _0681_ _0682_ net35 _0695_ VPWR VGND sg13g2_a22oi_1
XFILLER_39_502 VPWR VGND sg13g2_decap_4
XFILLER_7_196 VPWR VGND sg13g2_decap_8
X_1582_ VGND VPWR net96 daisychain\[105\] _0631_ net72 sg13g2_a21oi_1
XFILLER_39_557 VPWR VGND sg13g2_fill_2
X_2065_ state\[125\] net23 VPWR VGND sg13g2_buf_1
XFILLER_35_785 VPWR VGND sg13g2_decap_8
XFILLER_35_796 VPWR VGND sg13g2_fill_2
X_1016_ VPWR _0010_ state\[109\] VGND sg13g2_inv_1
X_1918_ net190 VGND VPWR _0250_ daisychain\[122\] clknet_leaf_16_clk sg13g2_dfrbpq_1
X_1849_ net194 VGND VPWR _0181_ daisychain\[53\] clknet_leaf_15_clk sg13g2_dfrbpq_1
XFILLER_13_424 VPWR VGND sg13g2_decap_8
XFILLER_40_210 VPWR VGND sg13g2_decap_8
XFILLER_43_21 VPWR VGND sg13g2_decap_8
XFILLER_40_287 VPWR VGND sg13g2_decap_8
XFILLER_43_98 VPWR VGND sg13g2_decap_8
XFILLER_1_851 VPWR VGND sg13g2_decap_8
XFILLER_4_144 VPWR VGND sg13g2_decap_8
XFILLER_5_634 VPWR VGND sg13g2_decap_8
XFILLER_0_350 VPWR VGND sg13g2_decap_8
XFILLER_36_538 VPWR VGND sg13g2_decap_8
XFILLER_48_343 VPWR VGND sg13g2_decap_8
XFILLER_49_877 VPWR VGND sg13g2_decap_8
XFILLER_20_906 VPWR VGND sg13g2_decap_8
XFILLER_44_560 VPWR VGND sg13g2_decap_8
Xclkbuf_leaf_11_clk clknet_2_2__leaf_clk clknet_leaf_11_clk VPWR VGND sg13g2_buf_8
X_1703_ _0417_ VPWR _0291_ VGND net159 _0056_ sg13g2_o21ai_1
X_1634_ VGND VPWR net98 daisychain\[118\] _0670_ net75 sg13g2_a21oi_1
XFILLER_39_343 VPWR VGND sg13g2_decap_4
X_1565_ _0803_ net126 _0617_ _0618_ VPWR VGND sg13g2_a21o_1
X_1496_ net169 VPWR _0566_ VGND net124 state\[85\] sg13g2_o21ai_1
XFILLER_35_593 VPWR VGND sg13g2_decap_8
X_2048_ net222 VGND VPWR _0380_ state\[124\] clknet_leaf_9_clk sg13g2_dfrbpq_1
XFILLER_13_13 VPWR VGND sg13g2_decap_8
XFILLER_13_57 VPWR VGND sg13g2_fill_2
XFILLER_13_79 VPWR VGND sg13g2_fill_2
XFILLER_22_254 VPWR VGND sg13g2_decap_4
XFILLER_22_265 VPWR VGND sg13g2_fill_1
Xfanout36 net37 net36 VPWR VGND sg13g2_buf_1
Xfanout69 net70 net69 VPWR VGND sg13g2_buf_1
Xfanout58 net63 net58 VPWR VGND sg13g2_buf_1
Xfanout47 net48 net47 VPWR VGND sg13g2_buf_1
XFILLER_1_147 VPWR VGND sg13g2_decap_8
XFILLER_2_648 VPWR VGND sg13g2_decap_8
XFILLER_18_527 VPWR VGND sg13g2_decap_8
XFILLER_38_21 VPWR VGND sg13g2_decap_8
XFILLER_38_98 VPWR VGND sg13g2_decap_8
XFILLER_46_847 VPWR VGND sg13g2_decap_8
XFILLER_13_254 VPWR VGND sg13g2_decap_8
XFILLER_41_574 VPWR VGND sg13g2_decap_8
XFILLER_45_357 VPWR VGND sg13g2_decap_8
XFILLER_9_214 VPWR VGND sg13g2_decap_8
XFILLER_5_431 VPWR VGND sg13g2_decap_8
XFILLER_48_7 VPWR VGND sg13g2_decap_8
XFILLER_49_652 VPWR VGND sg13g2_decap_8
X_1350_ VGND VPWR net81 daisychain\[47\] _0457_ net42 sg13g2_a21oi_1
X_1281_ _0732_ net121 _0404_ _0405_ VPWR VGND sg13g2_a21o_1
XFILLER_48_140 VPWR VGND sg13g2_decap_8
Xclkbuf_leaf_0_clk clknet_2_1__leaf_clk clknet_leaf_0_clk VPWR VGND sg13g2_buf_8
XFILLER_32_541 VPWR VGND sg13g2_decap_8
XFILLER_32_563 VPWR VGND sg13g2_fill_1
X_0996_ VPWR _0115_ state\[89\] VGND sg13g2_inv_1
XFILLER_8_291 VPWR VGND sg13g2_decap_8
Xfanout204 net206 net204 VPWR VGND sg13g2_buf_1
X_1617_ _0816_ net142 _0656_ _0657_ VPWR VGND sg13g2_a21o_1
XFILLER_39_140 VPWR VGND sg13g2_decap_8
Xfanout215 net216 net215 VPWR VGND sg13g2_buf_1
Xfanout226 net227 net226 VPWR VGND sg13g2_buf_1
X_1548_ net171 VPWR _0605_ VGND net126 state\[98\] sg13g2_o21ai_1
X_1479_ _0208_ _0552_ _0553_ net47 _0781_ VPWR VGND sg13g2_a22oi_1
XFILLER_11_714 VPWR VGND sg13g2_decap_8
XFILLER_24_34 VPWR VGND sg13g2_decap_8
XFILLER_10_246 VPWR VGND sg13g2_decap_8
XFILLER_40_77 VPWR VGND sg13g2_decap_8
XFILLER_6_228 VPWR VGND sg13g2_decap_8
XFILLER_2_445 VPWR VGND sg13g2_decap_8
XFILLER_49_53 VPWR VGND sg13g2_decap_8
XFILLER_1_49 VPWR VGND sg13g2_decap_8
XFILLER_45_154 VPWR VGND sg13g2_decap_8
XFILLER_46_644 VPWR VGND sg13g2_decap_8
XFILLER_42_883 VPWR VGND sg13g2_decap_8
XFILLER_6_762 VPWR VGND sg13g2_decap_8
X_1402_ VGND VPWR net78 daisychain\[60\] _0496_ net36 sg13g2_a21oi_1
XFILLER_49_471 VPWR VGND sg13g2_decap_8
Xinput4 ui_in[2] net4 VPWR VGND sg13g2_buf_1
X_1333_ _0745_ net115 _0443_ _0444_ VPWR VGND sg13g2_a21o_1
X_1264_ net163 VPWR _0392_ VGND net118 state\[27\] sg13g2_o21ai_1
XFILLER_17_390 VPWR VGND sg13g2_decap_4
XFILLER_20_500 VPWR VGND sg13g2_decap_8
XFILLER_36_165 VPWR VGND sg13g2_decap_8
XFILLER_37_688 VPWR VGND sg13g2_fill_1
Xclkbuf_2_1__f_clk clknet_2_1__leaf_clk clknet_0_clk VPWR VGND sg13g2_buf_16
X_1195_ _0137_ _0853_ _0854_ net68 _0710_ VPWR VGND sg13g2_a22oi_1
XFILLER_20_544 VPWR VGND sg13g2_decap_8
XFILLER_20_577 VPWR VGND sg13g2_fill_1
X_0979_ VPWR _0097_ state\[72\] VGND sg13g2_inv_1
XFILLER_10_36 VPWR VGND sg13g2_decap_8
XFILLER_27_121 VPWR VGND sg13g2_decap_8
XFILLER_35_11 VPWR VGND sg13g2_decap_8
XFILLER_15_349 VPWR VGND sg13g2_fill_2
XFILLER_35_88 VPWR VGND sg13g2_decap_8
XFILLER_42_168 VPWR VGND sg13g2_decap_8
XFILLER_43_658 VPWR VGND sg13g2_decap_8
XFILLER_11_588 VPWR VGND sg13g2_fill_1
XFILLER_3_732 VPWR VGND sg13g2_decap_8
XFILLER_7_537 VPWR VGND sg13g2_decap_8
XFILLER_2_242 VPWR VGND sg13g2_decap_8
XFILLER_39_909 VPWR VGND sg13g2_decap_8
XFILLER_18_132 VPWR VGND sg13g2_decap_8
XFILLER_33_102 VPWR VGND sg13g2_decap_8
XFILLER_33_179 VPWR VGND sg13g2_decap_8
XFILLER_34_603 VPWR VGND sg13g2_decap_8
XFILLER_46_441 VPWR VGND sg13g2_decap_8
XFILLER_30_897 VPWR VGND sg13g2_decap_8
XFILLER_42_691 VPWR VGND sg13g2_fill_2
X_1951_ net208 VGND VPWR _0283_ state\[27\] clknet_leaf_13_clk sg13g2_dfrbpq_1
X_1882_ net211 VGND VPWR _0214_ daisychain\[86\] clknet_leaf_5_clk sg13g2_dfrbpq_1
X_0902_ VPWR _0698_ daisychain\[124\] VGND sg13g2_inv_1
XFILLER_37_0 VPWR VGND sg13g2_decap_8
XFILLER_6_592 VPWR VGND sg13g2_decap_8
XFILLER_2_81 VPWR VGND sg13g2_decap_8
X_1316_ net161 VPWR _0431_ VGND net117 state\[40\] sg13g2_o21ai_1
X_1247_ _0150_ _0892_ _0893_ net64 _0723_ VPWR VGND sg13g2_a22oi_1
X_1178_ VGND VPWR net93 daisychain\[4\] _0842_ net67 sg13g2_a21oi_1
XFILLER_24_157 VPWR VGND sg13g2_decap_8
XFILLER_40_606 VPWR VGND sg13g2_decap_8
XFILLER_21_13 VPWR VGND sg13g2_fill_1
XFILLER_21_57 VPWR VGND sg13g2_decap_8
XFILLER_4_529 VPWR VGND sg13g2_decap_8
XFILLER_0_779 VPWR VGND sg13g2_decap_8
XFILLER_48_728 VPWR VGND sg13g2_decap_4
XFILLER_15_124 VPWR VGND sg13g2_decap_8
XFILLER_43_455 VPWR VGND sg13g2_decap_8
XFILLER_46_21 VPWR VGND sg13g2_decap_8
XFILLER_46_98 VPWR VGND sg13g2_decap_8
XFILLER_47_238 VPWR VGND sg13g2_decap_8
XFILLER_30_127 VPWR VGND sg13g2_decap_8
XFILLER_7_301 VPWR VGND sg13g2_decap_8
XFILLER_7_378 VPWR VGND sg13g2_decap_8
XFILLER_38_238 VPWR VGND sg13g2_decap_8
X_1101_ VPWR _0770_ daisychain\[69\] VGND sg13g2_inv_1
X_1032_ VPWR _0701_ daisychain\[0\] VGND sg13g2_inv_1
XFILLER_21_127 VPWR VGND sg13g2_decap_8
X_1934_ net221 VGND VPWR _0266_ state\[10\] clknet_leaf_10_clk sg13g2_dfrbpq_1
X_1865_ net199 VGND VPWR _0197_ daisychain\[69\] clknet_leaf_3_clk sg13g2_dfrbpq_1
X_1796_ net222 VGND VPWR _0128_ daisychain\[0\] clknet_leaf_9_clk sg13g2_dfrbpq_1
XFILLER_16_57 VPWR VGND sg13g2_fill_2
XFILLER_20_160 VPWR VGND sg13g2_decap_8
XFILLER_32_67 VPWR VGND sg13g2_decap_8
XFILLER_40_414 VPWR VGND sg13g2_decap_8
XFILLER_8_109 VPWR VGND sg13g2_decap_8
XFILLER_4_326 VPWR VGND sg13g2_decap_8
XFILLER_5_816 VPWR VGND sg13g2_decap_8
XFILLER_0_532 VPWR VGND sg13g2_decap_8
XFILLER_48_525 VPWR VGND sg13g2_decap_8
XFILLER_32_915 VPWR VGND sg13g2_decap_8
XFILLER_32_926 VPWR VGND sg13g2_fill_1
XFILLER_43_252 VPWR VGND sg13g2_decap_8
XFILLER_44_764 VPWR VGND sg13g2_decap_8
XFILLER_7_175 VPWR VGND sg13g2_decap_8
X_1650_ VGND VPWR net78 daisychain\[122\] _0682_ net35 sg13g2_a21oi_1
X_1581_ _0807_ net139 _0629_ _0630_ VPWR VGND sg13g2_a21o_1
XFILLER_39_514 VPWR VGND sg13g2_fill_2
XFILLER_4_893 VPWR VGND sg13g2_decap_8
XFILLER_19_260 VPWR VGND sg13g2_decap_8
XFILLER_26_208 VPWR VGND sg13g2_fill_2
XFILLER_35_742 VPWR VGND sg13g2_fill_1
XFILLER_35_764 VPWR VGND sg13g2_fill_2
X_2064_ state\[124\] net22 VPWR VGND sg13g2_buf_1
X_1015_ VPWR _0009_ state\[108\] VGND sg13g2_inv_1
XFILLER_34_263 VPWR VGND sg13g2_fill_2
X_1917_ net190 VGND VPWR _0249_ daisychain\[121\] clknet_leaf_16_clk sg13g2_dfrbpq_1
XFILLER_1_329 VPWR VGND sg13g2_decap_8
X_1848_ net197 VGND VPWR _0180_ daisychain\[52\] clknet_leaf_15_clk sg13g2_dfrbpq_1
X_1779_ _0645_ VPWR _0367_ VGND net184 _0013_ sg13g2_o21ai_1
XFILLER_25_230 VPWR VGND sg13g2_decap_4
XFILLER_41_723 VPWR VGND sg13g2_decap_8
XFILLER_41_745 VPWR VGND sg13g2_fill_1
XFILLER_45_539 VPWR VGND sg13g2_decap_8
XFILLER_40_266 VPWR VGND sg13g2_decap_8
XFILLER_43_77 VPWR VGND sg13g2_decap_8
XFILLER_4_123 VPWR VGND sg13g2_decap_8
XFILLER_5_613 VPWR VGND sg13g2_decap_8
XFILLER_9_429 VPWR VGND sg13g2_decap_8
XFILLER_1_830 VPWR VGND sg13g2_decap_8
XFILLER_36_506 VPWR VGND sg13g2_decap_4
XFILLER_48_322 VPWR VGND sg13g2_decap_8
XFILLER_48_399 VPWR VGND sg13g2_decap_8
XFILLER_49_856 VPWR VGND sg13g2_decap_8
XFILLER_16_252 VPWR VGND sg13g2_decap_8
XFILLER_31_200 VPWR VGND sg13g2_decap_8
XFILLER_32_712 VPWR VGND sg13g2_fill_2
XFILLER_32_723 VPWR VGND sg13g2_fill_1
XFILLER_32_734 VPWR VGND sg13g2_decap_8
Xdigitalen2.g\[0\].u.inv1 VPWR digitalen2.g\[0\].u.OUTN net8 VGND sg13g2_inv_1
X_1702_ _0414_ VPWR _0290_ VGND net159 _0055_ sg13g2_o21ai_1
X_1633_ _0820_ net144 _0668_ _0669_ VPWR VGND sg13g2_a21o_1
X_1564_ net182 VPWR _0617_ VGND net128 state\[102\] sg13g2_o21ai_1
XFILLER_39_322 VPWR VGND sg13g2_decap_8
XFILLER_4_690 VPWR VGND sg13g2_decap_8
X_1495_ _0212_ _0564_ _0565_ net46 _0785_ VPWR VGND sg13g2_a22oi_1
X_2047_ net221 VGND VPWR _0379_ state\[123\] clknet_leaf_10_clk sg13g2_dfrbpq_1
Xfanout37 _0826_ net37 VPWR VGND sg13g2_buf_1
Xfanout59 net61 net59 VPWR VGND sg13g2_buf_1
Xfanout48 _0826_ net48 VPWR VGND sg13g2_buf_1
XFILLER_1_126 VPWR VGND sg13g2_decap_8
XFILLER_2_627 VPWR VGND sg13g2_decap_8
XFILLER_38_77 VPWR VGND sg13g2_decap_8
XFILLER_45_336 VPWR VGND sg13g2_decap_8
XFILLER_46_826 VPWR VGND sg13g2_decap_8
XFILLER_13_233 VPWR VGND sg13g2_decap_8
XFILLER_41_553 VPWR VGND sg13g2_fill_1
XFILLER_41_586 VPWR VGND sg13g2_decap_8
XFILLER_5_410 VPWR VGND sg13g2_decap_8
XFILLER_5_487 VPWR VGND sg13g2_decap_8
XFILLER_49_631 VPWR VGND sg13g2_decap_8
X_1280_ net165 VPWR _0404_ VGND net120 state\[31\] sg13g2_o21ai_1
XFILLER_36_369 VPWR VGND sg13g2_fill_1
XFILLER_48_196 VPWR VGND sg13g2_decap_8
XFILLER_8_270 VPWR VGND sg13g2_decap_8
X_0995_ VPWR _0114_ state\[88\] VGND sg13g2_inv_1
XFILLER_5_81 VPWR VGND sg13g2_decap_8
Xfanout205 net206 net205 VPWR VGND sg13g2_buf_1
Xfanout216 net231 net216 VPWR VGND sg13g2_buf_1
Xfanout227 net230 net227 VPWR VGND sg13g2_buf_1
X_1616_ net185 VPWR _0656_ VGND net142 state\[115\] sg13g2_o21ai_1
X_1547_ _0225_ _0603_ _0604_ net60 _0798_ VPWR VGND sg13g2_a22oi_1
XFILLER_39_196 VPWR VGND sg13g2_decap_8
X_1478_ VGND VPWR net82 daisychain\[79\] _0553_ net47 sg13g2_a21oi_1
XFILLER_10_225 VPWR VGND sg13g2_decap_8
XFILLER_24_13 VPWR VGND sg13g2_decap_8
XFILLER_3_914 VPWR VGND sg13g2_decap_8
XFILLER_3_925 VPWR VGND sg13g2_fill_2
XFILLER_40_56 VPWR VGND sg13g2_decap_8
XFILLER_6_207 VPWR VGND sg13g2_decap_8
XFILLER_1_28 VPWR VGND sg13g2_decap_8
XFILLER_2_424 VPWR VGND sg13g2_decap_8
XFILLER_49_32 VPWR VGND sg13g2_decap_8
XFILLER_6_4 VPWR VGND sg13g2_decap_8
XFILLER_18_336 VPWR VGND sg13g2_decap_8
XFILLER_18_347 VPWR VGND sg13g2_fill_2
XFILLER_45_133 VPWR VGND sg13g2_decap_8
XFILLER_46_623 VPWR VGND sg13g2_decap_8
XFILLER_41_350 VPWR VGND sg13g2_decap_4
XFILLER_41_372 VPWR VGND sg13g2_decap_8
XFILLER_42_862 VPWR VGND sg13g2_decap_8
XFILLER_5_284 VPWR VGND sg13g2_decap_8
XFILLER_6_741 VPWR VGND sg13g2_decap_8
X_1401_ _0762_ net102 _0494_ _0495_ VPWR VGND sg13g2_a21o_1
XFILLER_36_144 VPWR VGND sg13g2_decap_8
XFILLER_49_450 VPWR VGND sg13g2_decap_8
Xinput5 ui_in[3] net5 VPWR VGND sg13g2_buf_1
X_1332_ net160 VPWR _0443_ VGND net115 state\[44\] sg13g2_o21ai_1
X_1263_ _0154_ _0390_ _0391_ net53 _0727_ VPWR VGND sg13g2_a22oi_1
X_1194_ VGND VPWR net93 daisychain\[8\] _0854_ net68 sg13g2_a21oi_1
XFILLER_33_840 VPWR VGND sg13g2_decap_4
XFILLER_10_15 VPWR VGND sg13g2_decap_8
X_0978_ VPWR _0096_ state\[71\] VGND sg13g2_inv_1
XFILLER_19_79 VPWR VGND sg13g2_decap_8
XFILLER_27_100 VPWR VGND sg13g2_decap_8
XFILLER_27_177 VPWR VGND sg13g2_decap_8
XFILLER_27_188 VPWR VGND sg13g2_fill_2
XFILLER_35_67 VPWR VGND sg13g2_decap_8
XFILLER_43_637 VPWR VGND sg13g2_decap_8
XFILLER_42_147 VPWR VGND sg13g2_decap_8
XFILLER_7_516 VPWR VGND sg13g2_decap_8
XFILLER_2_221 VPWR VGND sg13g2_decap_8
XFILLER_3_711 VPWR VGND sg13g2_decap_8
XFILLER_3_788 VPWR VGND sg13g2_decap_8
XFILLER_18_111 VPWR VGND sg13g2_decap_8
XFILLER_19_612 VPWR VGND sg13g2_fill_1
XFILLER_2_298 VPWR VGND sg13g2_decap_8
XFILLER_46_420 VPWR VGND sg13g2_decap_8
XFILLER_47_910 VPWR VGND sg13g2_decap_8
XFILLER_15_873 VPWR VGND sg13g2_decap_8
XFILLER_18_188 VPWR VGND sg13g2_decap_8
XFILLER_33_158 VPWR VGND sg13g2_decap_8
XFILLER_46_497 VPWR VGND sg13g2_decap_8
X_1950_ net208 VGND VPWR _0282_ state\[26\] clknet_leaf_11_clk sg13g2_dfrbpq_1
XFILLER_6_571 VPWR VGND sg13g2_decap_8
X_1881_ net211 VGND VPWR _0213_ daisychain\[85\] clknet_leaf_5_clk sg13g2_dfrbpq_1
X_0901_ VPWR _0697_ daisychain\[125\] VGND sg13g2_inv_1
X_1315_ _0167_ _0429_ _0430_ net51 _0740_ VPWR VGND sg13g2_a22oi_1
XFILLER_2_60 VPWR VGND sg13g2_decap_8
XFILLER_49_291 VPWR VGND sg13g2_decap_8
X_1246_ VGND VPWR net92 daisychain\[21\] _0893_ net65 sg13g2_a21oi_1
X_1177_ _0706_ net133 _0840_ _0841_ VPWR VGND sg13g2_a21o_1
XFILLER_20_331 VPWR VGND sg13g2_fill_1
XFILLER_24_136 VPWR VGND sg13g2_decap_8
XFILLER_33_681 VPWR VGND sg13g2_fill_1
XFILLER_21_36 VPWR VGND sg13g2_decap_8
XFILLER_4_508 VPWR VGND sg13g2_decap_8
XFILLER_0_758 VPWR VGND sg13g2_decap_8
XFILLER_47_217 VPWR VGND sg13g2_decap_8
XFILLER_48_707 VPWR VGND sg13g2_decap_8
XFILLER_12_821 VPWR VGND sg13g2_fill_2
XFILLER_15_103 VPWR VGND sg13g2_decap_8
XFILLER_30_106 VPWR VGND sg13g2_decap_8
XFILLER_43_434 VPWR VGND sg13g2_decap_8
XFILLER_46_77 VPWR VGND sg13g2_decap_8
XFILLER_11_331 VPWR VGND sg13g2_decap_8
XFILLER_11_397 VPWR VGND sg13g2_fill_1
XFILLER_12_854 VPWR VGND sg13g2_decap_4
XFILLER_12_865 VPWR VGND sg13g2_decap_8
XFILLER_23_180 VPWR VGND sg13g2_decap_8
XFILLER_7_357 VPWR VGND sg13g2_decap_8
XFILLER_7_49 VPWR VGND sg13g2_decap_8
XFILLER_8_814 VPWR VGND sg13g2_fill_2
XFILLER_30_8 VPWR VGND sg13g2_fill_2
XFILLER_3_585 VPWR VGND sg13g2_decap_8
XFILLER_38_217 VPWR VGND sg13g2_decap_8
XFILLER_46_294 VPWR VGND sg13g2_decap_8
XFILLER_47_784 VPWR VGND sg13g2_decap_8
X_1100_ VPWR _0769_ daisychain\[68\] VGND sg13g2_inv_1
X_1031_ VPWR _0027_ state\[124\] VGND sg13g2_inv_1
XFILLER_14_180 VPWR VGND sg13g2_decap_8
XFILLER_21_106 VPWR VGND sg13g2_decap_8
XFILLER_30_662 VPWR VGND sg13g2_decap_8
XFILLER_34_445 VPWR VGND sg13g2_fill_1
X_1933_ net221 VGND VPWR _0265_ state\[9\] clknet_leaf_10_clk sg13g2_dfrbpq_1
X_1864_ net198 VGND VPWR _0196_ daisychain\[68\] clknet_leaf_3_clk sg13g2_dfrbpq_1
X_1795_ _0693_ VPWR _0383_ VGND net158 _0030_ sg13g2_o21ai_1
XFILLER_29_217 VPWR VGND sg13g2_fill_2
XFILLER_37_294 VPWR VGND sg13g2_decap_8
XFILLER_38_795 VPWR VGND sg13g2_fill_2
X_1229_ _0719_ net138 _0879_ _0880_ VPWR VGND sg13g2_a21o_1
XFILLER_32_46 VPWR VGND sg13g2_decap_8
XFILLER_4_305 VPWR VGND sg13g2_decap_8
XFILLER_0_511 VPWR VGND sg13g2_decap_8
XFILLER_28_261 VPWR VGND sg13g2_fill_1
XFILLER_28_283 VPWR VGND sg13g2_fill_1
XFILLER_48_504 VPWR VGND sg13g2_decap_8
XFILLER_43_231 VPWR VGND sg13g2_decap_8
XFILLER_44_743 VPWR VGND sg13g2_decap_8
XFILLER_12_684 VPWR VGND sg13g2_decap_4
XFILLER_7_154 VPWR VGND sg13g2_decap_8
XFILLER_8_644 VPWR VGND sg13g2_fill_1
X_1580_ net182 VPWR _0629_ VGND net139 state\[106\] sg13g2_o21ai_1
XFILLER_21_4 VPWR VGND sg13g2_fill_1
XFILLER_39_559 VPWR VGND sg13g2_fill_1
XFILLER_3_382 VPWR VGND sg13g2_decap_8
XFILLER_4_872 VPWR VGND sg13g2_decap_8
XFILLER_34_242 VPWR VGND sg13g2_fill_2
XFILLER_47_581 VPWR VGND sg13g2_decap_8
X_2063_ state\[123\] net21 VPWR VGND sg13g2_buf_1
X_1014_ VPWR _0008_ state\[107\] VGND sg13g2_inv_1
XFILLER_8_81 VPWR VGND sg13g2_decap_8
X_1916_ net229 VGND VPWR _0248_ daisychain\[120\] clknet_leaf_7_clk sg13g2_dfrbpq_1
X_1847_ net195 VGND VPWR _0179_ daisychain\[51\] clknet_leaf_15_clk sg13g2_dfrbpq_1
XFILLER_1_308 VPWR VGND sg13g2_decap_8
XFILLER_2_809 VPWR VGND sg13g2_decap_8
X_1778_ _0642_ VPWR _0366_ VGND net184 _0012_ sg13g2_o21ai_1
XFILLER_17_209 VPWR VGND sg13g2_decap_8
XFILLER_27_13 VPWR VGND sg13g2_decap_8
XFILLER_27_24 VPWR VGND sg13g2_fill_2
XFILLER_45_518 VPWR VGND sg13g2_decap_8
XFILLER_13_415 VPWR VGND sg13g2_fill_1
XFILLER_14_916 VPWR VGND sg13g2_decap_8
XFILLER_27_79 VPWR VGND sg13g2_decap_8
XFILLER_40_245 VPWR VGND sg13g2_decap_8
XFILLER_41_735 VPWR VGND sg13g2_decap_4
XFILLER_43_56 VPWR VGND sg13g2_decap_8
XFILLER_9_408 VPWR VGND sg13g2_decap_8
XFILLER_4_102 VPWR VGND sg13g2_decap_8
XFILLER_5_669 VPWR VGND sg13g2_decap_8
XFILLER_0_385 VPWR VGND sg13g2_decap_8
XFILLER_1_886 VPWR VGND sg13g2_decap_8
XFILLER_48_301 VPWR VGND sg13g2_decap_8
XFILLER_49_802 VPWR VGND sg13g2_decap_8
XFILLER_49_813 VPWR VGND sg13g2_fill_2
XFILLER_49_835 VPWR VGND sg13g2_decap_8
XFILLER_4_179 VPWR VGND sg13g2_decap_8
XFILLER_4_39 VPWR VGND sg13g2_decap_8
XFILLER_16_231 VPWR VGND sg13g2_decap_8
XFILLER_17_90 VPWR VGND sg13g2_decap_8
XFILLER_48_378 VPWR VGND sg13g2_decap_8
XFILLER_31_256 VPWR VGND sg13g2_fill_2
XFILLER_31_289 VPWR VGND sg13g2_fill_1
XFILLER_40_790 VPWR VGND sg13g2_decap_4
XFILLER_44_595 VPWR VGND sg13g2_decap_8
XFILLER_8_452 VPWR VGND sg13g2_decap_8
Xdigitalen2.g\[0\].u.inv2 VPWR digitalen2.g\[0\].u.OUTP digitalen2.g\[0\].u.OUTN VGND
+ sg13g2_inv_1
X_1701_ _0411_ VPWR _0289_ VGND net161 _0054_ sg13g2_o21ai_1
X_1632_ net187 VPWR _0668_ VGND net144 state\[119\] sg13g2_o21ai_1
X_1563_ _0229_ _0615_ _0616_ net61 _0802_ VPWR VGND sg13g2_a22oi_1
X_1494_ VGND VPWR net82 daisychain\[83\] _0565_ net46 sg13g2_a21oi_1
XFILLER_39_301 VPWR VGND sg13g2_decap_8
XFILLER_48_890 VPWR VGND sg13g2_decap_8
X_2046_ net218 VGND VPWR _0378_ state\[122\] clknet_leaf_9_clk sg13g2_dfrbpq_1
Xfanout49 net50 net49 VPWR VGND sg13g2_buf_1
Xfanout38 net39 net38 VPWR VGND sg13g2_buf_1
XFILLER_13_59 VPWR VGND sg13g2_fill_1
XFILLER_2_606 VPWR VGND sg13g2_decap_8
XFILLER_1_105 VPWR VGND sg13g2_decap_8
XFILLER_49_109 VPWR VGND sg13g2_decap_8
XFILLER_18_507 VPWR VGND sg13g2_decap_4
XFILLER_38_56 VPWR VGND sg13g2_decap_8
XFILLER_45_315 VPWR VGND sg13g2_decap_8
XFILLER_46_805 VPWR VGND sg13g2_decap_8
XFILLER_13_212 VPWR VGND sg13g2_decap_8
XFILLER_9_249 VPWR VGND sg13g2_decap_8
XFILLER_5_466 VPWR VGND sg13g2_decap_8
XFILLER_6_923 VPWR VGND sg13g2_decap_4
XFILLER_0_182 VPWR VGND sg13g2_decap_8
XFILLER_1_683 VPWR VGND sg13g2_decap_8
XFILLER_48_175 VPWR VGND sg13g2_decap_8
XFILLER_49_610 VPWR VGND sg13g2_decap_8
XFILLER_49_687 VPWR VGND sg13g2_decap_8
Xdigitalen3.g\[2\].u.inv1 VPWR digitalen3.g\[2\].u.OUTN net9 VGND sg13g2_inv_1
XFILLER_44_392 VPWR VGND sg13g2_decap_8
XFILLER_45_882 VPWR VGND sg13g2_decap_8
XFILLER_13_790 VPWR VGND sg13g2_fill_1
X_0994_ VPWR _0113_ state\[87\] VGND sg13g2_inv_1
XFILLER_9_761 VPWR VGND sg13g2_fill_1
XFILLER_5_60 VPWR VGND sg13g2_decap_8
Xfanout206 net210 net206 VPWR VGND sg13g2_buf_1
Xfanout217 net219 net217 VPWR VGND sg13g2_buf_1
Xfanout228 net229 net228 VPWR VGND sg13g2_buf_1
X_1615_ _0242_ _0654_ _0655_ net74 _0815_ VPWR VGND sg13g2_a22oi_1
X_1546_ VGND VPWR net88 daisychain\[96\] _0604_ net60 sg13g2_a21oi_1
X_1477_ _0781_ net125 _0551_ _0552_ VPWR VGND sg13g2_a21o_1
XFILLER_39_175 VPWR VGND sg13g2_decap_8
XFILLER_43_819 VPWR VGND sg13g2_decap_8
XFILLER_10_204 VPWR VGND sg13g2_decap_8
XFILLER_42_329 VPWR VGND sg13g2_decap_8
X_2029_ net225 VGND VPWR _0361_ state\[105\] clknet_leaf_6_clk sg13g2_dfrbpq_1
XFILLER_2_403 VPWR VGND sg13g2_decap_8
XFILLER_40_35 VPWR VGND sg13g2_decap_8
XFILLER_49_11 VPWR VGND sg13g2_decap_8
XFILLER_46_602 VPWR VGND sg13g2_decap_8
XFILLER_49_88 VPWR VGND sg13g2_decap_8
XFILLER_42_841 VPWR VGND sg13g2_decap_8
XFILLER_45_112 VPWR VGND sg13g2_decap_8
XFILLER_45_189 VPWR VGND sg13g2_decap_8
XFILLER_46_679 VPWR VGND sg13g2_decap_8
XFILLER_1_480 VPWR VGND sg13g2_decap_8
XFILLER_5_263 VPWR VGND sg13g2_decap_8
XFILLER_6_797 VPWR VGND sg13g2_decap_8
Xwires VGND i_out dac/VbiasP[0] dac/VbiasP[1] dac/VbiasP[2] dac/VbiasP[3] dac/VbiasP[4]
+ dac/VbiasP[5] dac/VbiasP[6] dac/VbiasP[7] i_in input_mirror
X_1400_ net148 VPWR _0494_ VGND net104 state\[61\] sg13g2_o21ai_1
X_1331_ _0171_ _0441_ _0442_ net49 _0744_ VPWR VGND sg13g2_a22oi_1
XFILLER_36_123 VPWR VGND sg13g2_decap_8
XFILLER_37_602 VPWR VGND sg13g2_decap_8
Xinput6 ui_in[4] net6 VPWR VGND sg13g2_buf_1
X_1262_ VGND VPWR net85 daisychain\[25\] _0391_ net53 sg13g2_a21oi_1
X_1193_ _0710_ net134 _0852_ _0853_ VPWR VGND sg13g2_a21o_1
XFILLER_32_373 VPWR VGND sg13g2_decap_4
X_0977_ VPWR _0095_ state\[70\] VGND sg13g2_inv_1
XFILLER_0_918 VPWR VGND sg13g2_decap_8
XFILLER_19_58 VPWR VGND sg13g2_decap_8
X_1529_ _0794_ net123 _0590_ _0591_ VPWR VGND sg13g2_a21o_1
XFILLER_15_318 VPWR VGND sg13g2_decap_4
XFILLER_27_156 VPWR VGND sg13g2_decap_8
XFILLER_35_46 VPWR VGND sg13g2_decap_8
XFILLER_42_126 VPWR VGND sg13g2_decap_8
XFILLER_43_616 VPWR VGND sg13g2_decap_8
XFILLER_2_200 VPWR VGND sg13g2_decap_8
XFILLER_2_277 VPWR VGND sg13g2_decap_8
XFILLER_3_767 VPWR VGND sg13g2_decap_8
XFILLER_18_167 VPWR VGND sg13g2_decap_8
XFILLER_46_476 VPWR VGND sg13g2_decap_8
XFILLER_15_841 VPWR VGND sg13g2_decap_8
XFILLER_25_90 VPWR VGND sg13g2_decap_8
XFILLER_33_137 VPWR VGND sg13g2_decap_8
XFILLER_42_693 VPWR VGND sg13g2_fill_1
X_1880_ net201 VGND VPWR _0212_ daisychain\[84\] clknet_leaf_2_clk sg13g2_dfrbpq_1
X_0900_ VPWR _0028_ state\[125\] VGND sg13g2_inv_1
XFILLER_30_888 VPWR VGND sg13g2_decap_4
XFILLER_6_550 VPWR VGND sg13g2_decap_8
X_1314_ VGND VPWR net87 daisychain\[38\] _0430_ net50 sg13g2_a21oi_1
XFILLER_24_115 VPWR VGND sg13g2_decap_8
XFILLER_49_270 VPWR VGND sg13g2_decap_8
X_1245_ _0723_ net130 _0891_ _0892_ VPWR VGND sg13g2_a21o_1
X_1176_ net178 VPWR _0840_ VGND net133 state\[5\] sg13g2_o21ai_1
XFILLER_20_343 VPWR VGND sg13g2_decap_4
XFILLER_20_387 VPWR VGND sg13g2_fill_2
XFILLER_33_671 VPWR VGND sg13g2_fill_1
XFILLER_0_737 VPWR VGND sg13g2_decap_8
XFILLER_16_616 VPWR VGND sg13g2_fill_2
XFILLER_44_925 VPWR VGND sg13g2_fill_2
XFILLER_46_56 VPWR VGND sg13g2_decap_8
XFILLER_11_310 VPWR VGND sg13g2_decap_8
XFILLER_15_159 VPWR VGND sg13g2_decap_8
XFILLER_43_413 VPWR VGND sg13g2_decap_8
XFILLER_11_387 VPWR VGND sg13g2_fill_2
XFILLER_7_28 VPWR VGND sg13g2_decap_8
XFILLER_7_336 VPWR VGND sg13g2_decap_8
XFILLER_23_8 VPWR VGND sg13g2_fill_1
XFILLER_3_564 VPWR VGND sg13g2_decap_8
XFILLER_46_273 VPWR VGND sg13g2_decap_8
XFILLER_47_763 VPWR VGND sg13g2_decap_8
X_1030_ VPWR _0026_ state\[123\] VGND sg13g2_inv_1
X_1932_ net221 VGND VPWR _0264_ state\[8\] clknet_leaf_10_clk sg13g2_dfrbpq_1
X_1863_ net198 VGND VPWR _0195_ daisychain\[67\] clknet_leaf_1_clk sg13g2_dfrbpq_1
XFILLER_42_0 VPWR VGND sg13g2_decap_8
X_1794_ _0690_ VPWR _0382_ VGND net146 _0029_ sg13g2_o21ai_1
XFILLER_38_763 VPWR VGND sg13g2_fill_2
XFILLER_38_774 VPWR VGND sg13g2_decap_8
X_1228_ net176 VPWR _0879_ VGND net138 state\[18\] sg13g2_o21ai_1
XFILLER_12_129 VPWR VGND sg13g2_decap_8
XFILLER_16_37 VPWR VGND sg13g2_decap_4
XFILLER_37_273 VPWR VGND sg13g2_decap_8
XFILLER_40_449 VPWR VGND sg13g2_decap_8
XFILLER_41_906 VPWR VGND sg13g2_decap_8
X_1159_ _0128_ _0827_ _0825_ net69 _0701_ VPWR VGND sg13g2_a22oi_1
XFILLER_20_195 VPWR VGND sg13g2_decap_4
XFILLER_32_25 VPWR VGND sg13g2_decap_8
XFILLER_0_567 VPWR VGND sg13g2_fill_2
XFILLER_0_589 VPWR VGND sg13g2_decap_8
XFILLER_17_925 VPWR VGND sg13g2_fill_2
XFILLER_43_210 VPWR VGND sg13g2_decap_8
XFILLER_44_722 VPWR VGND sg13g2_decap_8
XFILLER_12_663 VPWR VGND sg13g2_decap_8
XFILLER_31_427 VPWR VGND sg13g2_decap_8
XFILLER_31_449 VPWR VGND sg13g2_decap_4
XFILLER_43_287 VPWR VGND sg13g2_decap_8
XFILLER_44_799 VPWR VGND sg13g2_decap_8
XFILLER_8_612 VPWR VGND sg13g2_fill_2
XFILLER_8_656 VPWR VGND sg13g2_fill_1
XFILLER_11_184 VPWR VGND sg13g2_decap_8
XFILLER_3_361 VPWR VGND sg13g2_decap_8
XFILLER_4_851 VPWR VGND sg13g2_decap_8
XFILLER_7_133 VPWR VGND sg13g2_decap_8
XFILLER_8_689 VPWR VGND sg13g2_fill_2
XFILLER_14_4 VPWR VGND sg13g2_fill_1
XFILLER_39_516 VPWR VGND sg13g2_fill_1
X_2062_ state\[122\] net20 VPWR VGND sg13g2_buf_1
XFILLER_34_221 VPWR VGND sg13g2_decap_8
XFILLER_34_276 VPWR VGND sg13g2_decap_8
XFILLER_34_287 VPWR VGND sg13g2_fill_1
XFILLER_47_560 VPWR VGND sg13g2_decap_8
X_1013_ VPWR _0007_ state\[106\] VGND sg13g2_inv_1
XFILLER_8_60 VPWR VGND sg13g2_decap_8
Xclkbuf_leaf_14_clk clknet_2_0__leaf_clk clknet_leaf_14_clk VPWR VGND sg13g2_buf_8
X_1915_ net229 VGND VPWR _0247_ daisychain\[119\] clknet_leaf_8_clk sg13g2_dfrbpq_1
X_1846_ net195 VGND VPWR _0178_ daisychain\[50\] clknet_leaf_15_clk sg13g2_dfrbpq_1
X_1777_ _0639_ VPWR _0365_ VGND net182 _0010_ sg13g2_o21ai_1
XFILLER_27_58 VPWR VGND sg13g2_fill_1
XFILLER_40_224 VPWR VGND sg13g2_decap_8
XFILLER_43_35 VPWR VGND sg13g2_decap_8
XFILLER_4_158 VPWR VGND sg13g2_decap_8
XFILLER_4_18 VPWR VGND sg13g2_decap_8
XFILLER_5_648 VPWR VGND sg13g2_decap_8
XFILLER_0_364 VPWR VGND sg13g2_decap_8
XFILLER_1_865 VPWR VGND sg13g2_decap_8
XFILLER_48_357 VPWR VGND sg13g2_decap_8
XFILLER_16_210 VPWR VGND sg13g2_decap_8
XFILLER_32_758 VPWR VGND sg13g2_fill_1
XFILLER_44_574 VPWR VGND sg13g2_decap_8
XFILLER_31_246 VPWR VGND sg13g2_fill_2
XFILLER_8_431 VPWR VGND sg13g2_decap_8
X_1700_ _0408_ VPWR _0288_ VGND net165 _0053_ sg13g2_o21ai_1
X_1631_ _0246_ _0666_ _0667_ net75 _0819_ VPWR VGND sg13g2_a22oi_1
Xclkbuf_leaf_3_clk clknet_2_1__leaf_clk clknet_leaf_3_clk VPWR VGND sg13g2_buf_8
X_1562_ VGND VPWR net89 daisychain\[100\] _0616_ net61 sg13g2_a21oi_1
X_1493_ _0785_ net112 _0563_ _0564_ VPWR VGND sg13g2_a21o_1
XFILLER_35_541 VPWR VGND sg13g2_decap_8
X_2045_ net227 VGND VPWR _0377_ state\[121\] clknet_leaf_7_clk sg13g2_dfrbpq_1
XFILLER_35_552 VPWR VGND sg13g2_fill_1
XFILLER_35_563 VPWR VGND sg13g2_decap_4
Xfanout39 net48 net39 VPWR VGND sg13g2_buf_1
X_1829_ net207 VGND VPWR _0161_ daisychain\[33\] clknet_leaf_13_clk sg13g2_dfrbpq_1
XFILLER_38_35 VPWR VGND sg13g2_decap_8
XFILLER_14_747 VPWR VGND sg13g2_fill_1
XFILLER_41_500 VPWR VGND sg13g2_fill_1
XFILLER_13_268 VPWR VGND sg13g2_decap_8
XFILLER_41_544 VPWR VGND sg13g2_decap_8
XFILLER_6_902 VPWR VGND sg13g2_decap_8
XFILLER_9_228 VPWR VGND sg13g2_decap_8
XFILLER_1_662 VPWR VGND sg13g2_decap_8
XFILLER_5_445 VPWR VGND sg13g2_decap_8
Xdigitalen3.g\[2\].u.inv2 VPWR digitalen3.g\[2\].u.OUTP digitalen3.g\[2\].u.OUTN VGND
+ sg13g2_inv_1
XFILLER_0_161 VPWR VGND sg13g2_decap_8
XFILLER_36_305 VPWR VGND sg13g2_decap_8
XFILLER_48_154 VPWR VGND sg13g2_decap_8
XFILLER_49_666 VPWR VGND sg13g2_decap_8
XFILLER_32_500 VPWR VGND sg13g2_fill_2
XFILLER_44_371 VPWR VGND sg13g2_decap_8
XFILLER_45_861 VPWR VGND sg13g2_decap_8
X_0993_ VPWR _0112_ state\[86\] VGND sg13g2_inv_1
XFILLER_12_290 VPWR VGND sg13g2_decap_8
X_1614_ VGND VPWR net97 daisychain\[113\] _0655_ net74 sg13g2_a21oi_1
XFILLER_9_795 VPWR VGND sg13g2_decap_8
Xfanout207 net209 net207 VPWR VGND sg13g2_buf_1
Xfanout218 net219 net218 VPWR VGND sg13g2_buf_1
Xfanout229 net230 net229 VPWR VGND sg13g2_buf_1
X_1545_ _0798_ net126 _0602_ _0603_ VPWR VGND sg13g2_a21o_1
X_1476_ net170 VPWR _0551_ VGND net125 state\[80\] sg13g2_o21ai_1
XFILLER_36_861 VPWR VGND sg13g2_fill_1
XFILLER_39_154 VPWR VGND sg13g2_decap_8
XFILLER_42_308 VPWR VGND sg13g2_decap_8
X_2028_ net227 VGND VPWR _0360_ state\[104\] clknet_leaf_8_clk sg13g2_dfrbpq_1
XFILLER_24_48 VPWR VGND sg13g2_decap_8
XFILLER_40_14 VPWR VGND sg13g2_decap_8
XFILLER_2_459 VPWR VGND sg13g2_decap_8
XFILLER_46_658 VPWR VGND sg13g2_decap_8
XFILLER_49_67 VPWR VGND sg13g2_decap_8
XFILLER_14_500 VPWR VGND sg13g2_fill_2
XFILLER_14_522 VPWR VGND sg13g2_decap_4
XFILLER_14_555 VPWR VGND sg13g2_fill_1
XFILLER_33_308 VPWR VGND sg13g2_fill_1
XFILLER_42_820 VPWR VGND sg13g2_decap_8
XFILLER_42_897 VPWR VGND sg13g2_decap_8
XFILLER_45_168 VPWR VGND sg13g2_decap_8
XFILLER_10_772 VPWR VGND sg13g2_decap_4
XFILLER_10_783 VPWR VGND sg13g2_fill_2
XFILLER_14_81 VPWR VGND sg13g2_fill_2
XFILLER_5_242 VPWR VGND sg13g2_decap_8
XFILLER_6_776 VPWR VGND sg13g2_decap_8
XFILLER_46_7 VPWR VGND sg13g2_decap_8
X_1330_ VGND VPWR net87 daisychain\[42\] _0442_ net49 sg13g2_a21oi_1
X_1261_ _0727_ net118 _0389_ _0390_ VPWR VGND sg13g2_a21o_1
XFILLER_36_102 VPWR VGND sg13g2_decap_8
XFILLER_36_179 VPWR VGND sg13g2_decap_8
XFILLER_49_485 VPWR VGND sg13g2_decap_8
Xinput7 ui_in[5] net7 VPWR VGND sg13g2_buf_1
X_1192_ net177 VPWR _0852_ VGND net134 state\[9\] sg13g2_o21ai_1
XFILLER_20_558 VPWR VGND sg13g2_fill_2
XFILLER_32_352 VPWR VGND sg13g2_fill_2
XFILLER_33_864 VPWR VGND sg13g2_decap_8
X_0976_ VPWR _0093_ state\[69\] VGND sg13g2_inv_1
XFILLER_19_37 VPWR VGND sg13g2_fill_2
XFILLER_27_135 VPWR VGND sg13g2_decap_8
X_1528_ net167 VPWR _0590_ VGND net123 state\[93\] sg13g2_o21ai_1
X_1459_ _0203_ _0537_ _0538_ net45 _0776_ VPWR VGND sg13g2_a22oi_1
XFILLER_16_809 VPWR VGND sg13g2_fill_2
XFILLER_35_25 VPWR VGND sg13g2_decap_8
XFILLER_42_105 VPWR VGND sg13g2_decap_8
XFILLER_2_256 VPWR VGND sg13g2_decap_8
XFILLER_3_746 VPWR VGND sg13g2_decap_8
XFILLER_18_146 VPWR VGND sg13g2_decap_8
XFILLER_19_625 VPWR VGND sg13g2_fill_2
XFILLER_33_116 VPWR VGND sg13g2_decap_8
XFILLER_34_617 VPWR VGND sg13g2_fill_2
XFILLER_46_455 VPWR VGND sg13g2_decap_8
XFILLER_14_385 VPWR VGND sg13g2_decap_8
XFILLER_14_396 VPWR VGND sg13g2_decap_8
XFILLER_30_823 VPWR VGND sg13g2_decap_8
XFILLER_41_182 VPWR VGND sg13g2_decap_8
XFILLER_2_95 VPWR VGND sg13g2_decap_8
XFILLER_37_422 VPWR VGND sg13g2_decap_8
XFILLER_37_433 VPWR VGND sg13g2_fill_2
XFILLER_38_923 VPWR VGND sg13g2_decap_4
Xdigitalen1.g\[1\].u.inv1 VPWR digitalen1.g\[1\].u.OUTN net7 VGND sg13g2_inv_1
X_1313_ _0740_ net117 _0428_ _0429_ VPWR VGND sg13g2_a21o_1
X_1244_ net174 VPWR _0891_ VGND net130 state\[22\] sg13g2_o21ai_1
XFILLER_18_691 VPWR VGND sg13g2_decap_8
XFILLER_37_466 VPWR VGND sg13g2_fill_1
X_1175_ _0132_ _0838_ _0839_ net69 _0705_ VPWR VGND sg13g2_a22oi_1
XFILLER_20_311 VPWR VGND sg13g2_fill_1
XFILLER_20_322 VPWR VGND sg13g2_decap_4
XFILLER_32_193 VPWR VGND sg13g2_decap_8
X_0959_ VPWR _0075_ state\[52\] VGND sg13g2_inv_1
XFILLER_0_716 VPWR VGND sg13g2_decap_8
XFILLER_44_904 VPWR VGND sg13g2_decap_8
XFILLER_46_35 VPWR VGND sg13g2_decap_8
XFILLER_12_823 VPWR VGND sg13g2_fill_1
XFILLER_15_138 VPWR VGND sg13g2_decap_8
XFILLER_43_469 VPWR VGND sg13g2_decap_8
XFILLER_7_315 VPWR VGND sg13g2_decap_8
XFILLER_8_816 VPWR VGND sg13g2_fill_1
XFILLER_11_93 VPWR VGND sg13g2_decap_8
XFILLER_3_543 VPWR VGND sg13g2_decap_8
XFILLER_19_433 VPWR VGND sg13g2_decap_4
XFILLER_46_252 VPWR VGND sg13g2_decap_8
XFILLER_47_742 VPWR VGND sg13g2_decap_8
XFILLER_30_686 VPWR VGND sg13g2_fill_2
X_1931_ net220 VGND VPWR _0263_ state\[7\] clknet_leaf_10_clk sg13g2_dfrbpq_1
X_1862_ net192 VGND VPWR _0194_ daisychain\[66\] clknet_leaf_1_clk sg13g2_dfrbpq_1
X_1793_ _0687_ VPWR _0381_ VGND net187 _0028_ sg13g2_o21ai_1
XFILLER_37_252 VPWR VGND sg13g2_decap_8
XFILLER_38_797 VPWR VGND sg13g2_fill_1
X_1227_ _0145_ _0877_ _0878_ net66 _0718_ VPWR VGND sg13g2_a22oi_1
X_1158_ VGND VPWR net97 net2 _0827_ net76 sg13g2_a21oi_1
XFILLER_12_108 VPWR VGND sg13g2_decap_8
XFILLER_40_406 VPWR VGND sg13g2_fill_2
XFILLER_40_428 VPWR VGND sg13g2_decap_8
X_1089_ VPWR _0758_ daisychain\[57\] VGND sg13g2_inv_1
XFILLER_20_174 VPWR VGND sg13g2_decap_8
XFILLER_0_546 VPWR VGND sg13g2_decap_4
XFILLER_48_539 VPWR VGND sg13g2_decap_8
XFILLER_28_274 VPWR VGND sg13g2_decap_8
XFILLER_43_266 VPWR VGND sg13g2_decap_8
XFILLER_44_701 VPWR VGND sg13g2_decap_8
XFILLER_44_778 VPWR VGND sg13g2_decap_8
XFILLER_11_163 VPWR VGND sg13g2_decap_8
XFILLER_31_439 VPWR VGND sg13g2_decap_4
XFILLER_7_112 VPWR VGND sg13g2_decap_8
XFILLER_22_81 VPWR VGND sg13g2_decap_8
XFILLER_3_340 VPWR VGND sg13g2_decap_8
XFILLER_4_830 VPWR VGND sg13g2_decap_8
XFILLER_7_189 VPWR VGND sg13g2_decap_8
XFILLER_34_200 VPWR VGND sg13g2_decap_8
XFILLER_39_506 VPWR VGND sg13g2_fill_2
X_2061_ state\[121\] net19 VPWR VGND sg13g2_buf_1
X_1012_ VPWR _0006_ state\[105\] VGND sg13g2_inv_1
XFILLER_34_255 VPWR VGND sg13g2_fill_1
XFILLER_35_756 VPWR VGND sg13g2_fill_2
XFILLER_35_778 VPWR VGND sg13g2_decap_8
X_1914_ net230 VGND VPWR _0246_ daisychain\[118\] clknet_leaf_7_clk sg13g2_dfrbpq_1
X_1845_ net196 VGND VPWR _0177_ daisychain\[49\] clknet_leaf_14_clk sg13g2_dfrbpq_1
X_1776_ _0636_ VPWR _0364_ VGND net182 _0009_ sg13g2_o21ai_1
XFILLER_43_14 VPWR VGND sg13g2_decap_8
XFILLER_40_203 VPWR VGND sg13g2_decap_8
XFILLER_1_844 VPWR VGND sg13g2_decap_8
XFILLER_4_137 VPWR VGND sg13g2_decap_8
XFILLER_5_627 VPWR VGND sg13g2_decap_8
XFILLER_0_343 VPWR VGND sg13g2_decap_8
XFILLER_48_336 VPWR VGND sg13g2_decap_8
XFILLER_17_789 VPWR VGND sg13g2_fill_1
XFILLER_31_258 VPWR VGND sg13g2_fill_1
XFILLER_32_748 VPWR VGND sg13g2_decap_4
XFILLER_44_553 VPWR VGND sg13g2_decap_8
XFILLER_12_494 VPWR VGND sg13g2_decap_8
XFILLER_8_410 VPWR VGND sg13g2_decap_8
X_1630_ VGND VPWR net97 daisychain\[117\] _0667_ net75 sg13g2_a21oi_1
X_1561_ _0802_ net127 _0614_ _0615_ VPWR VGND sg13g2_a21o_1
X_1492_ net169 VPWR _0563_ VGND net112 state\[84\] sg13g2_o21ai_1
XFILLER_39_336 VPWR VGND sg13g2_decap_8
X_2044_ net229 VGND VPWR _0376_ state\[120\] clknet_leaf_7_clk sg13g2_dfrbpq_1
XFILLER_22_247 VPWR VGND sg13g2_fill_2
XFILLER_31_781 VPWR VGND sg13g2_decap_8
X_1828_ net209 VGND VPWR _0160_ daisychain\[32\] clknet_leaf_13_clk sg13g2_dfrbpq_1
X_1759_ _0585_ VPWR _0347_ VGND net168 _0118_ sg13g2_o21ai_1
XFILLER_38_14 VPWR VGND sg13g2_decap_8
XFILLER_39_881 VPWR VGND sg13g2_decap_8
XFILLER_13_247 VPWR VGND sg13g2_decap_8
XFILLER_9_207 VPWR VGND sg13g2_decap_8
XFILLER_10_910 VPWR VGND sg13g2_decap_8
XFILLER_5_424 VPWR VGND sg13g2_decap_8
XFILLER_0_140 VPWR VGND sg13g2_decap_8
XFILLER_1_641 VPWR VGND sg13g2_decap_8
XFILLER_28_91 VPWR VGND sg13g2_decap_8
XFILLER_44_350 VPWR VGND sg13g2_decap_8
XFILLER_45_840 VPWR VGND sg13g2_decap_8
XFILLER_48_133 VPWR VGND sg13g2_decap_8
XFILLER_49_645 VPWR VGND sg13g2_decap_8
XFILLER_20_729 VPWR VGND sg13g2_fill_1
XFILLER_32_534 VPWR VGND sg13g2_decap_8
XFILLER_32_556 VPWR VGND sg13g2_fill_2
X_0992_ VPWR _0111_ state\[85\] VGND sg13g2_inv_1
XFILLER_9_752 VPWR VGND sg13g2_decap_8
XFILLER_8_284 VPWR VGND sg13g2_decap_8
X_1613_ _0815_ net142 _0653_ _0654_ VPWR VGND sg13g2_a21o_1
X_1544_ net171 VPWR _0602_ VGND net126 state\[97\] sg13g2_o21ai_1
XFILLER_39_133 VPWR VGND sg13g2_decap_8
XFILLER_5_95 VPWR VGND sg13g2_decap_8
Xfanout208 net209 net208 VPWR VGND sg13g2_buf_1
Xfanout219 net224 net219 VPWR VGND sg13g2_buf_1
X_1475_ _0207_ _0549_ _0550_ net47 _0780_ VPWR VGND sg13g2_a22oi_1
XFILLER_11_707 VPWR VGND sg13g2_decap_8
XFILLER_24_27 VPWR VGND sg13g2_decap_8
X_2027_ net216 VGND VPWR _0359_ state\[103\] clknet_leaf_8_clk sg13g2_dfrbpq_1
XFILLER_10_239 VPWR VGND sg13g2_decap_8
XFILLER_11_729 VPWR VGND sg13g2_fill_1
XFILLER_2_438 VPWR VGND sg13g2_decap_8
XFILLER_49_46 VPWR VGND sg13g2_decap_8
XFILLER_45_147 VPWR VGND sg13g2_decap_8
XFILLER_46_637 VPWR VGND sg13g2_decap_8
XFILLER_42_876 VPWR VGND sg13g2_decap_8
XFILLER_10_795 VPWR VGND sg13g2_fill_1
XFILLER_30_92 VPWR VGND sg13g2_decap_8
XFILLER_5_221 VPWR VGND sg13g2_decap_8
XFILLER_5_298 VPWR VGND sg13g2_decap_8
XFILLER_6_755 VPWR VGND sg13g2_decap_8
XFILLER_39_7 VPWR VGND sg13g2_decap_8
XFILLER_49_464 VPWR VGND sg13g2_decap_8
Xinput8 ui_in[6] net8 VPWR VGND sg13g2_buf_1
X_1260_ net163 VPWR _0389_ VGND net118 state\[26\] sg13g2_o21ai_1
X_1191_ _0136_ _0850_ _0851_ net68 _0709_ VPWR VGND sg13g2_a22oi_1
XFILLER_17_350 VPWR VGND sg13g2_fill_2
XFILLER_17_394 VPWR VGND sg13g2_fill_2
XFILLER_32_331 VPWR VGND sg13g2_fill_1
XFILLER_36_158 VPWR VGND sg13g2_decap_8
XFILLER_37_659 VPWR VGND sg13g2_decap_4
X_0975_ VPWR _0092_ state\[68\] VGND sg13g2_inv_1
XFILLER_10_29 VPWR VGND sg13g2_decap_8
X_1527_ _0220_ _0588_ _0589_ net59 _0793_ VPWR VGND sg13g2_a22oi_1
XFILLER_27_114 VPWR VGND sg13g2_decap_8
X_1458_ VGND VPWR net82 daisychain\[74\] _0538_ net45 sg13g2_a21oi_1
X_1389_ _0759_ net105 _0485_ _0486_ VPWR VGND sg13g2_a21o_1
XFILLER_11_515 VPWR VGND sg13g2_decap_4
XFILLER_36_692 VPWR VGND sg13g2_fill_2
XFILLER_3_725 VPWR VGND sg13g2_decap_8
XFILLER_2_235 VPWR VGND sg13g2_decap_8
XFILLER_47_924 VPWR VGND sg13g2_fill_2
XFILLER_4_4 VPWR VGND sg13g2_decap_8
XFILLER_14_320 VPWR VGND sg13g2_decap_8
XFILLER_18_125 VPWR VGND sg13g2_decap_8
XFILLER_26_180 VPWR VGND sg13g2_decap_8
XFILLER_46_434 VPWR VGND sg13g2_decap_8
XFILLER_15_887 VPWR VGND sg13g2_fill_1
XFILLER_41_161 VPWR VGND sg13g2_decap_8
XFILLER_42_651 VPWR VGND sg13g2_decap_4
XFILLER_42_684 VPWR VGND sg13g2_decap_8
XFILLER_41_91 VPWR VGND sg13g2_decap_8
XFILLER_6_585 VPWR VGND sg13g2_decap_8
XFILLER_2_74 VPWR VGND sg13g2_decap_8
XFILLER_38_902 VPWR VGND sg13g2_decap_8
Xdigitalen1.g\[1\].u.inv2 VPWR digitalen1.g\[1\].u.OUTP digitalen1.g\[1\].u.OUTN VGND
+ sg13g2_inv_1
X_1312_ net161 VPWR _0428_ VGND net117 state\[39\] sg13g2_o21ai_1
X_1243_ _0149_ _0889_ _0890_ net65 _0722_ VPWR VGND sg13g2_a22oi_1
X_1174_ VGND VPWR net93 daisychain\[3\] _0839_ net69 sg13g2_a21oi_1
XFILLER_32_172 VPWR VGND sg13g2_decap_8
XFILLER_33_662 VPWR VGND sg13g2_decap_4
XFILLER_20_356 VPWR VGND sg13g2_fill_1
X_0958_ VPWR _0074_ state\[51\] VGND sg13g2_inv_1
XFILLER_15_117 VPWR VGND sg13g2_decap_8
XFILLER_16_618 VPWR VGND sg13g2_fill_1
XFILLER_43_448 VPWR VGND sg13g2_decap_8
XFILLER_46_14 VPWR VGND sg13g2_decap_8
XFILLER_11_345 VPWR VGND sg13g2_decap_4
XFILLER_11_389 VPWR VGND sg13g2_fill_1
XFILLER_12_879 VPWR VGND sg13g2_fill_2
XFILLER_23_194 VPWR VGND sg13g2_decap_8
XFILLER_8_839 VPWR VGND sg13g2_decap_4
XFILLER_11_72 VPWR VGND sg13g2_decap_8
XFILLER_3_522 VPWR VGND sg13g2_decap_8
XFILLER_3_599 VPWR VGND sg13g2_decap_8
XFILLER_46_231 VPWR VGND sg13g2_decap_8
XFILLER_47_721 VPWR VGND sg13g2_decap_8
XFILLER_15_695 VPWR VGND sg13g2_decap_4
XFILLER_30_632 VPWR VGND sg13g2_fill_2
XFILLER_42_481 VPWR VGND sg13g2_decap_8
XFILLER_47_798 VPWR VGND sg13g2_decap_8
X_1930_ net220 VGND VPWR _0262_ state\[6\] clknet_leaf_10_clk sg13g2_dfrbpq_1
XFILLER_14_194 VPWR VGND sg13g2_decap_8
Xdigitalen2.g\[3\].u.inv1 VPWR digitalen2.g\[3\].u.OUTN net8 VGND sg13g2_inv_1
X_1861_ net192 VGND VPWR _0193_ daisychain\[65\] clknet_leaf_1_clk sg13g2_dfrbpq_1
X_1792_ _0684_ VPWR _0380_ VGND net179 _0027_ sg13g2_o21ai_1
XFILLER_29_209 VPWR VGND sg13g2_fill_2
XFILLER_6_382 VPWR VGND sg13g2_decap_8
XFILLER_37_231 VPWR VGND sg13g2_decap_8
XFILLER_38_710 VPWR VGND sg13g2_fill_2
XFILLER_38_765 VPWR VGND sg13g2_fill_1
X_1226_ VGND VPWR net95 daisychain\[16\] _0878_ net66 sg13g2_a21oi_1
X_1157_ net147 net3 _0826_ VPWR VGND sg13g2_nor2_1
XFILLER_20_153 VPWR VGND sg13g2_decap_8
X_1088_ VPWR _0757_ daisychain\[56\] VGND sg13g2_inv_1
XFILLER_4_319 VPWR VGND sg13g2_decap_8
XFILLER_5_809 VPWR VGND sg13g2_decap_8
XFILLER_0_525 VPWR VGND sg13g2_decap_8
XFILLER_48_518 VPWR VGND sg13g2_decap_8
XFILLER_16_404 VPWR VGND sg13g2_fill_1
XFILLER_32_908 VPWR VGND sg13g2_decap_8
XFILLER_43_245 VPWR VGND sg13g2_decap_8
XFILLER_44_757 VPWR VGND sg13g2_decap_8
XFILLER_11_142 VPWR VGND sg13g2_decap_8
XFILLER_12_643 VPWR VGND sg13g2_fill_1
XFILLER_22_60 VPWR VGND sg13g2_decap_8
XFILLER_7_168 VPWR VGND sg13g2_decap_8
XFILLER_8_614 VPWR VGND sg13g2_fill_1
XFILLER_3_396 VPWR VGND sg13g2_decap_8
XFILLER_4_886 VPWR VGND sg13g2_decap_8
XFILLER_19_242 VPWR VGND sg13g2_decap_8
XFILLER_35_702 VPWR VGND sg13g2_decap_8
XFILLER_47_595 VPWR VGND sg13g2_decap_8
X_2060_ state\[120\] net18 VPWR VGND sg13g2_buf_1
X_1011_ VPWR _0005_ state\[104\] VGND sg13g2_inv_1
X_1913_ net230 VGND VPWR _0245_ daisychain\[117\] clknet_leaf_7_clk sg13g2_dfrbpq_1
XFILLER_30_484 VPWR VGND sg13g2_fill_1
XFILLER_8_95 VPWR VGND sg13g2_decap_8
X_1844_ net196 VGND VPWR _0176_ daisychain\[48\] clknet_leaf_14_clk sg13g2_dfrbpq_1
X_1775_ _0633_ VPWR _0363_ VGND net182 _0008_ sg13g2_o21ai_1
XFILLER_25_223 VPWR VGND sg13g2_decap_8
XFILLER_25_234 VPWR VGND sg13g2_fill_2
X_1209_ _0714_ net136 _0864_ _0865_ VPWR VGND sg13g2_a21o_1
XFILLER_40_259 VPWR VGND sg13g2_decap_8
XFILLER_5_606 VPWR VGND sg13g2_decap_8
XFILLER_0_322 VPWR VGND sg13g2_decap_8
XFILLER_4_116 VPWR VGND sg13g2_decap_8
XFILLER_0_399 VPWR VGND sg13g2_fill_1
XFILLER_44_532 VPWR VGND sg13g2_decap_8
XFILLER_48_315 VPWR VGND sg13g2_decap_8
XFILLER_49_849 VPWR VGND sg13g2_decap_8
XFILLER_16_245 VPWR VGND sg13g2_decap_8
XFILLER_17_779 VPWR VGND sg13g2_decap_4
XFILLER_31_248 VPWR VGND sg13g2_fill_1
XFILLER_32_705 VPWR VGND sg13g2_decap_8
XFILLER_32_727 VPWR VGND sg13g2_decap_8
XFILLER_33_81 VPWR VGND sg13g2_decap_8
XFILLER_8_466 VPWR VGND sg13g2_decap_4
XFILLER_8_499 VPWR VGND sg13g2_fill_1
X_1560_ net171 VPWR _0614_ VGND net126 state\[101\] sg13g2_o21ai_1
XFILLER_39_315 VPWR VGND sg13g2_decap_8
XFILLER_3_193 VPWR VGND sg13g2_decap_8
XFILLER_4_683 VPWR VGND sg13g2_decap_8
X_1491_ _0211_ _0561_ _0562_ net56 _0784_ VPWR VGND sg13g2_a22oi_1
XFILLER_47_392 VPWR VGND sg13g2_decap_8
X_2043_ net229 VGND VPWR _0375_ state\[119\] clknet_leaf_8_clk sg13g2_dfrbpq_1
XFILLER_31_771 VPWR VGND sg13g2_decap_8
X_1827_ net209 VGND VPWR _0159_ daisychain\[31\] clknet_leaf_13_clk sg13g2_dfrbpq_1
XFILLER_1_119 VPWR VGND sg13g2_decap_8
X_1758_ _0582_ VPWR _0346_ VGND net168 _0117_ sg13g2_o21ai_1
X_1689_ _0889_ VPWR _0277_ VGND net174 _0041_ sg13g2_o21ai_1
XFILLER_39_860 VPWR VGND sg13g2_decap_8
XFILLER_45_329 VPWR VGND sg13g2_decap_8
XFILLER_46_819 VPWR VGND sg13g2_decap_8
XFILLER_13_226 VPWR VGND sg13g2_decap_8
XFILLER_41_535 VPWR VGND sg13g2_decap_4
XFILLER_5_403 VPWR VGND sg13g2_decap_8
XFILLER_0_196 VPWR VGND sg13g2_decap_8
XFILLER_1_620 VPWR VGND sg13g2_decap_8
XFILLER_1_697 VPWR VGND sg13g2_decap_8
XFILLER_48_112 VPWR VGND sg13g2_decap_8
XFILLER_49_624 VPWR VGND sg13g2_decap_8
XFILLER_45_896 VPWR VGND sg13g2_decap_8
XFILLER_48_189 VPWR VGND sg13g2_decap_8
XFILLER_44_91 VPWR VGND sg13g2_decap_8
XFILLER_8_263 VPWR VGND sg13g2_decap_8
X_0991_ VPWR _0110_ state\[84\] VGND sg13g2_inv_1
XFILLER_4_480 VPWR VGND sg13g2_decap_8
XFILLER_5_74 VPWR VGND sg13g2_decap_8
Xfanout209 net210 net209 VPWR VGND sg13g2_buf_1
X_1612_ net185 VPWR _0653_ VGND net142 state\[114\] sg13g2_o21ai_1
X_1543_ _0224_ _0600_ _0601_ net62 _0797_ VPWR VGND sg13g2_a22oi_1
X_1474_ VGND VPWR net82 daisychain\[78\] _0550_ net47 sg13g2_a21oi_1
XFILLER_39_112 VPWR VGND sg13g2_decap_8
XFILLER_39_189 VPWR VGND sg13g2_decap_8
XFILLER_36_885 VPWR VGND sg13g2_fill_2
X_2026_ net216 VGND VPWR _0358_ state\[102\] clknet_leaf_8_clk sg13g2_dfrbpq_1
XFILLER_10_218 VPWR VGND sg13g2_decap_8
XFILLER_3_907 VPWR VGND sg13g2_decap_8
XFILLER_40_49 VPWR VGND sg13g2_decap_8
XFILLER_2_417 VPWR VGND sg13g2_decap_8
XFILLER_49_25 VPWR VGND sg13g2_decap_8
XFILLER_45_126 VPWR VGND sg13g2_decap_8
XFILLER_46_616 VPWR VGND sg13g2_decap_8
XFILLER_14_83 VPWR VGND sg13g2_fill_1
XFILLER_41_343 VPWR VGND sg13g2_decap_8
XFILLER_41_365 VPWR VGND sg13g2_decap_8
XFILLER_42_855 VPWR VGND sg13g2_decap_8
XFILLER_30_71 VPWR VGND sg13g2_decap_8
XFILLER_5_200 VPWR VGND sg13g2_decap_8
XFILLER_5_277 VPWR VGND sg13g2_decap_8
XFILLER_6_723 VPWR VGND sg13g2_fill_1
XFILLER_6_734 VPWR VGND sg13g2_decap_8
XFILLER_1_494 VPWR VGND sg13g2_decap_8
XFILLER_37_616 VPWR VGND sg13g2_fill_2
XFILLER_39_91 VPWR VGND sg13g2_decap_8
XFILLER_49_443 VPWR VGND sg13g2_decap_8
Xinput9 ui_in[7] net9 VPWR VGND sg13g2_buf_1
X_1190_ VGND VPWR net93 daisychain\[7\] _0851_ net68 sg13g2_a21oi_1
XFILLER_17_340 VPWR VGND sg13g2_fill_1
XFILLER_18_841 VPWR VGND sg13g2_decap_8
XFILLER_32_343 VPWR VGND sg13g2_fill_2
XFILLER_32_354 VPWR VGND sg13g2_fill_1
XFILLER_33_833 VPWR VGND sg13g2_decap_8
XFILLER_33_844 VPWR VGND sg13g2_fill_2
XFILLER_33_888 VPWR VGND sg13g2_decap_4
XFILLER_36_137 VPWR VGND sg13g2_decap_8
XFILLER_45_693 VPWR VGND sg13g2_decap_8
XFILLER_20_516 VPWR VGND sg13g2_fill_1
X_0974_ VPWR _0091_ state\[67\] VGND sg13g2_inv_1
XFILLER_9_572 VPWR VGND sg13g2_fill_1
XFILLER_9_561 VPWR VGND sg13g2_decap_4
X_1526_ VGND VPWR net88 daisychain\[91\] _0589_ net59 sg13g2_a21oi_1
X_1457_ _0776_ net111 _0536_ _0537_ VPWR VGND sg13g2_a21o_1
X_1388_ net149 VPWR _0485_ VGND net105 state\[58\] sg13g2_o21ai_1
XFILLER_7_509 VPWR VGND sg13g2_decap_8
X_2009_ net211 VGND VPWR _0341_ state\[85\] clknet_leaf_5_clk sg13g2_dfrbpq_1
XFILLER_2_214 VPWR VGND sg13g2_decap_8
XFILLER_3_704 VPWR VGND sg13g2_decap_8
XFILLER_18_104 VPWR VGND sg13g2_decap_8
XFILLER_19_605 VPWR VGND sg13g2_decap_8
XFILLER_46_413 VPWR VGND sg13g2_decap_8
XFILLER_47_903 VPWR VGND sg13g2_decap_8
XFILLER_15_855 VPWR VGND sg13g2_fill_2
XFILLER_34_619 VPWR VGND sg13g2_fill_1
XFILLER_41_140 VPWR VGND sg13g2_decap_8
XFILLER_41_70 VPWR VGND sg13g2_decap_8
XFILLER_2_781 VPWR VGND sg13g2_decap_8
XFILLER_6_564 VPWR VGND sg13g2_decap_8
X_1311_ _0166_ _0426_ _0427_ net50 _0739_ VPWR VGND sg13g2_a22oi_1
XFILLER_18_671 VPWR VGND sg13g2_fill_1
XFILLER_1_280 VPWR VGND sg13g2_decap_8
XFILLER_2_53 VPWR VGND sg13g2_decap_8
XFILLER_49_284 VPWR VGND sg13g2_decap_8
X_1242_ VGND VPWR net92 daisychain\[20\] _0890_ net65 sg13g2_a21oi_1
X_1173_ _0705_ net135 _0837_ _0838_ VPWR VGND sg13g2_a21o_1
XFILLER_17_181 VPWR VGND sg13g2_decap_8
XFILLER_24_129 VPWR VGND sg13g2_decap_8
XFILLER_32_151 VPWR VGND sg13g2_decap_8
XFILLER_33_641 VPWR VGND sg13g2_fill_2
XFILLER_45_490 VPWR VGND sg13g2_decap_8
XFILLER_20_368 VPWR VGND sg13g2_fill_2
XFILLER_21_29 VPWR VGND sg13g2_decap_8
X_0957_ VPWR _0073_ state\[50\] VGND sg13g2_inv_1
X_1509_ _0789_ net123 _0575_ _0576_ VPWR VGND sg13g2_a21o_1
XFILLER_43_427 VPWR VGND sg13g2_decap_8
XFILLER_11_324 VPWR VGND sg13g2_decap_8
XFILLER_12_858 VPWR VGND sg13g2_fill_2
XFILLER_23_173 VPWR VGND sg13g2_decap_8
XFILLER_3_501 VPWR VGND sg13g2_decap_8
XFILLER_3_578 VPWR VGND sg13g2_decap_8
XFILLER_19_402 VPWR VGND sg13g2_fill_2
XFILLER_19_413 VPWR VGND sg13g2_fill_1
XFILLER_46_210 VPWR VGND sg13g2_decap_8
XFILLER_47_700 VPWR VGND sg13g2_decap_8
XFILLER_47_777 VPWR VGND sg13g2_decap_8
XFILLER_14_173 VPWR VGND sg13g2_decap_8
XFILLER_15_652 VPWR VGND sg13g2_decap_8
XFILLER_15_685 VPWR VGND sg13g2_decap_4
XFILLER_30_600 VPWR VGND sg13g2_decap_8
XFILLER_30_611 VPWR VGND sg13g2_fill_2
XFILLER_34_438 VPWR VGND sg13g2_decap_8
XFILLER_36_81 VPWR VGND sg13g2_decap_8
XFILLER_46_287 VPWR VGND sg13g2_decap_8
X_1860_ net198 VGND VPWR _0192_ daisychain\[64\] clknet_leaf_1_clk sg13g2_dfrbpq_1
XFILLER_6_361 VPWR VGND sg13g2_decap_8
Xdigitalen2.g\[3\].u.inv2 VPWR digitalen2.g\[3\].u.OUTP digitalen2.g\[3\].u.OUTN VGND
+ sg13g2_inv_1
X_1791_ _0681_ VPWR _0379_ VGND net179 _0026_ sg13g2_o21ai_1
XFILLER_38_722 VPWR VGND sg13g2_decap_4
XFILLER_37_210 VPWR VGND sg13g2_decap_8
XFILLER_37_287 VPWR VGND sg13g2_decap_8
XFILLER_38_755 VPWR VGND sg13g2_fill_1
XFILLER_38_788 VPWR VGND sg13g2_decap_8
XFILLER_40_408 VPWR VGND sg13g2_fill_1
X_1225_ _0718_ net132 _0876_ _0877_ VPWR VGND sg13g2_a21o_1
X_1156_ _0701_ net136 _0824_ _0825_ VPWR VGND sg13g2_a21o_1
X_1087_ VPWR _0756_ daisychain\[55\] VGND sg13g2_inv_1
XFILLER_20_132 VPWR VGND sg13g2_decap_8
XFILLER_32_39 VPWR VGND sg13g2_decap_8
XFILLER_33_471 VPWR VGND sg13g2_fill_1
X_1989_ net192 VGND VPWR _0321_ state\[65\] clknet_leaf_1_clk sg13g2_dfrbpq_1
XFILLER_0_504 VPWR VGND sg13g2_decap_8
XFILLER_11_121 VPWR VGND sg13g2_decap_8
XFILLER_31_419 VPWR VGND sg13g2_fill_1
XFILLER_40_920 VPWR VGND sg13g2_decap_8
XFILLER_43_224 VPWR VGND sg13g2_decap_8
XFILLER_44_736 VPWR VGND sg13g2_decap_8
XFILLER_11_198 VPWR VGND sg13g2_decap_8
XFILLER_12_677 VPWR VGND sg13g2_decap_8
XFILLER_12_688 VPWR VGND sg13g2_fill_2
XFILLER_7_147 VPWR VGND sg13g2_decap_8
XFILLER_3_375 VPWR VGND sg13g2_decap_8
XFILLER_4_865 VPWR VGND sg13g2_decap_8
XFILLER_34_235 VPWR VGND sg13g2_decap_8
XFILLER_47_574 VPWR VGND sg13g2_decap_8
XFILLER_47_91 VPWR VGND sg13g2_decap_8
X_1010_ VPWR _0004_ state\[103\] VGND sg13g2_inv_1
XFILLER_30_441 VPWR VGND sg13g2_decap_4
XFILLER_43_791 VPWR VGND sg13g2_decap_8
XFILLER_8_74 VPWR VGND sg13g2_decap_8
X_1912_ net228 VGND VPWR _0244_ daisychain\[116\] clknet_leaf_6_clk sg13g2_dfrbpq_1
X_1843_ net196 VGND VPWR _0175_ daisychain\[47\] clknet_leaf_14_clk sg13g2_dfrbpq_1
XFILLER_40_0 VPWR VGND sg13g2_decap_8
Xclkbuf_leaf_6_clk clknet_2_3__leaf_clk clknet_leaf_6_clk VPWR VGND sg13g2_buf_8
X_1774_ _0630_ VPWR _0362_ VGND net182 _0007_ sg13g2_o21ai_1
X_1208_ net180 VPWR _0864_ VGND net136 state\[13\] sg13g2_o21ai_1
XFILLER_14_909 VPWR VGND sg13g2_decap_8
XFILLER_25_202 VPWR VGND sg13g2_decap_8
XFILLER_40_238 VPWR VGND sg13g2_decap_8
XFILLER_41_739 VPWR VGND sg13g2_fill_1
XFILLER_43_49 VPWR VGND sg13g2_decap_8
X_1139_ VPWR _0808_ daisychain\[107\] VGND sg13g2_inv_1
XFILLER_0_301 VPWR VGND sg13g2_decap_8
XFILLER_0_378 VPWR VGND sg13g2_decap_8
XFILLER_1_802 VPWR VGND sg13g2_decap_8
XFILLER_1_879 VPWR VGND sg13g2_decap_8
XFILLER_49_828 VPWR VGND sg13g2_decap_8
XFILLER_16_224 VPWR VGND sg13g2_decap_8
XFILLER_17_769 VPWR VGND sg13g2_fill_1
XFILLER_17_83 VPWR VGND sg13g2_decap_8
XFILLER_44_511 VPWR VGND sg13g2_decap_8
XFILLER_33_60 VPWR VGND sg13g2_decap_8
XFILLER_40_783 VPWR VGND sg13g2_decap_8
XFILLER_40_794 VPWR VGND sg13g2_fill_2
XFILLER_44_588 VPWR VGND sg13g2_decap_8
XFILLER_8_445 VPWR VGND sg13g2_decap_8
XFILLER_9_924 VPWR VGND sg13g2_fill_2
XFILLER_3_172 VPWR VGND sg13g2_decap_8
XFILLER_4_662 VPWR VGND sg13g2_decap_8
X_1490_ VGND VPWR net90 daisychain\[82\] _0562_ net56 sg13g2_a21oi_1
XFILLER_0_890 VPWR VGND sg13g2_decap_8
XFILLER_12_4 VPWR VGND sg13g2_fill_1
X_2042_ net230 VGND VPWR _0374_ state\[118\] clknet_leaf_7_clk sg13g2_dfrbpq_1
XFILLER_22_227 VPWR VGND sg13g2_fill_2
XFILLER_22_249 VPWR VGND sg13g2_fill_1
XFILLER_35_533 VPWR VGND sg13g2_fill_1
XFILLER_47_371 VPWR VGND sg13g2_decap_8
XFILLER_48_883 VPWR VGND sg13g2_decap_8
XFILLER_31_794 VPWR VGND sg13g2_fill_1
Xdigitalen0.g\[2\].u.inv1 VPWR digitalen0.g\[2\].u.OUTN net6 VGND sg13g2_inv_1
X_1826_ net209 VGND VPWR _0158_ daisychain\[30\] clknet_leaf_13_clk sg13g2_dfrbpq_1
X_1757_ _0579_ VPWR _0345_ VGND net168 _0115_ sg13g2_o21ai_1
X_1688_ _0886_ VPWR _0276_ VGND net174 _0040_ sg13g2_o21ai_1
XFILLER_38_49 VPWR VGND sg13g2_decap_8
XFILLER_45_308 VPWR VGND sg13g2_decap_8
XFILLER_13_205 VPWR VGND sg13g2_decap_8
XFILLER_5_459 VPWR VGND sg13g2_decap_8
XFILLER_6_916 VPWR VGND sg13g2_decap_8
XFILLER_0_175 VPWR VGND sg13g2_decap_8
XFILLER_1_676 VPWR VGND sg13g2_decap_8
XFILLER_48_168 VPWR VGND sg13g2_decap_8
XFILLER_49_603 VPWR VGND sg13g2_decap_8
XFILLER_36_319 VPWR VGND sg13g2_fill_1
XFILLER_44_385 VPWR VGND sg13g2_decap_8
XFILLER_44_70 VPWR VGND sg13g2_decap_8
XFILLER_45_875 VPWR VGND sg13g2_decap_8
XFILLER_32_569 VPWR VGND sg13g2_fill_1
XFILLER_8_242 VPWR VGND sg13g2_decap_8
X_1611_ _0241_ _0651_ _0652_ net74 _0814_ VPWR VGND sg13g2_a22oi_1
X_0990_ VPWR _0109_ state\[83\] VGND sg13g2_inv_1
XFILLER_5_53 VPWR VGND sg13g2_decap_8
X_1542_ VGND VPWR net89 daisychain\[95\] _0601_ net62 sg13g2_a21oi_1
X_1473_ _0780_ net113 _0548_ _0549_ VPWR VGND sg13g2_a21o_1
XFILLER_36_820 VPWR VGND sg13g2_decap_8
XFILLER_39_168 VPWR VGND sg13g2_decap_8
X_2025_ net214 VGND VPWR _0357_ state\[101\] clknet_leaf_6_clk sg13g2_dfrbpq_1
XFILLER_35_374 VPWR VGND sg13g2_decap_4
XFILLER_36_897 VPWR VGND sg13g2_decap_8
XFILLER_40_28 VPWR VGND sg13g2_decap_8
X_1809_ net222 VGND VPWR _0141_ daisychain\[13\] clknet_leaf_9_clk sg13g2_dfrbpq_1
XFILLER_41_322 VPWR VGND sg13g2_decap_8
XFILLER_42_834 VPWR VGND sg13g2_decap_8
XFILLER_45_105 VPWR VGND sg13g2_decap_8
XFILLER_14_73 VPWR VGND sg13g2_fill_2
XFILLER_41_388 VPWR VGND sg13g2_fill_1
XFILLER_6_702 VPWR VGND sg13g2_decap_8
XFILLER_30_50 VPWR VGND sg13g2_decap_8
XFILLER_5_256 VPWR VGND sg13g2_decap_8
XFILLER_18_820 VPWR VGND sg13g2_fill_2
XFILLER_1_473 VPWR VGND sg13g2_decap_8
XFILLER_36_116 VPWR VGND sg13g2_decap_8
XFILLER_39_70 VPWR VGND sg13g2_decap_8
XFILLER_49_422 VPWR VGND sg13g2_decap_8
XFILLER_49_499 VPWR VGND sg13g2_decap_8
XFILLER_17_352 VPWR VGND sg13g2_fill_1
XFILLER_17_385 VPWR VGND sg13g2_fill_2
XFILLER_18_886 VPWR VGND sg13g2_fill_2
XFILLER_20_528 VPWR VGND sg13g2_decap_8
XFILLER_32_311 VPWR VGND sg13g2_decap_4
XFILLER_32_322 VPWR VGND sg13g2_fill_2
XFILLER_32_366 VPWR VGND sg13g2_decap_8
XFILLER_32_377 VPWR VGND sg13g2_fill_1
XFILLER_33_878 VPWR VGND sg13g2_decap_4
XFILLER_44_182 VPWR VGND sg13g2_decap_8
XFILLER_45_672 VPWR VGND sg13g2_decap_8
X_0973_ VPWR _0090_ state\[66\] VGND sg13g2_inv_1
XFILLER_9_595 VPWR VGND sg13g2_decap_8
X_1525_ _0793_ net127 _0587_ _0588_ VPWR VGND sg13g2_a21o_1
X_1456_ net155 VPWR _0536_ VGND net111 state\[75\] sg13g2_o21ai_1
X_1387_ _0185_ _0483_ _0484_ net39 _0758_ VPWR VGND sg13g2_a22oi_1
XFILLER_27_149 VPWR VGND sg13g2_decap_8
XFILLER_35_39 VPWR VGND sg13g2_decap_8
XFILLER_42_119 VPWR VGND sg13g2_decap_8
XFILLER_43_609 VPWR VGND sg13g2_decap_8
X_2008_ net201 VGND VPWR _0340_ state\[84\] clknet_leaf_2_clk sg13g2_dfrbpq_1
XFILLER_35_193 VPWR VGND sg13g2_decap_8
XFILLER_19_639 VPWR VGND sg13g2_fill_2
XFILLER_47_926 VPWR VGND sg13g2_fill_1
XFILLER_15_834 VPWR VGND sg13g2_decap_8
XFILLER_25_83 VPWR VGND sg13g2_decap_8
XFILLER_30_837 VPWR VGND sg13g2_fill_1
XFILLER_46_469 VPWR VGND sg13g2_decap_8
XFILLER_41_196 VPWR VGND sg13g2_decap_8
XFILLER_6_543 VPWR VGND sg13g2_decap_8
XFILLER_2_32 VPWR VGND sg13g2_decap_8
XFILLER_2_760 VPWR VGND sg13g2_decap_8
XFILLER_44_7 VPWR VGND sg13g2_decap_8
X_1310_ VGND VPWR net87 daisychain\[37\] _0427_ net50 sg13g2_a21oi_1
X_1241_ _0722_ net131 _0888_ _0889_ VPWR VGND sg13g2_a21o_1
XFILLER_17_160 VPWR VGND sg13g2_decap_8
XFILLER_18_650 VPWR VGND sg13g2_fill_1
XFILLER_24_108 VPWR VGND sg13g2_decap_8
XFILLER_49_263 VPWR VGND sg13g2_decap_8
X_1172_ net179 VPWR _0837_ VGND net135 state\[4\] sg13g2_o21ai_1
XFILLER_20_347 VPWR VGND sg13g2_fill_1
XFILLER_32_130 VPWR VGND sg13g2_decap_8
XFILLER_33_686 VPWR VGND sg13g2_fill_1
X_0956_ VPWR _0071_ state\[49\] VGND sg13g2_inv_1
XFILLER_9_381 VPWR VGND sg13g2_decap_8
XFILLER_46_49 VPWR VGND sg13g2_decap_8
X_1508_ net167 VPWR _0575_ VGND net123 state\[88\] sg13g2_o21ai_1
X_1439_ _0198_ _0522_ _0523_ net44 _0771_ VPWR VGND sg13g2_a22oi_1
XFILLER_11_303 VPWR VGND sg13g2_decap_8
XFILLER_12_815 VPWR VGND sg13g2_fill_2
XFILLER_16_609 VPWR VGND sg13g2_decap_8
XFILLER_23_152 VPWR VGND sg13g2_decap_8
XFILLER_36_480 VPWR VGND sg13g2_fill_2
XFILLER_43_406 VPWR VGND sg13g2_decap_8
XFILLER_44_918 VPWR VGND sg13g2_decap_8
XFILLER_11_41 VPWR VGND sg13g2_decap_8
XFILLER_7_329 VPWR VGND sg13g2_decap_8
XFILLER_3_557 VPWR VGND sg13g2_decap_8
XFILLER_36_60 VPWR VGND sg13g2_decap_8
XFILLER_46_266 VPWR VGND sg13g2_decap_8
XFILLER_47_756 VPWR VGND sg13g2_decap_8
XFILLER_14_152 VPWR VGND sg13g2_decap_8
X_1790_ _0678_ VPWR _0378_ VGND net175 _0025_ sg13g2_o21ai_1
XFILLER_11_881 VPWR VGND sg13g2_decap_8
XFILLER_6_340 VPWR VGND sg13g2_decap_8
XFILLER_38_712 VPWR VGND sg13g2_fill_1
X_1224_ net176 VPWR _0876_ VGND net132 state\[17\] sg13g2_o21ai_1
XFILLER_37_266 VPWR VGND sg13g2_decap_8
X_1155_ net180 VPWR _0824_ VGND net136 state\[0\] sg13g2_o21ai_1
X_1086_ VPWR _0755_ daisychain\[54\] VGND sg13g2_inv_1
XFILLER_20_111 VPWR VGND sg13g2_decap_8
XFILLER_20_188 VPWR VGND sg13g2_decap_8
XFILLER_20_199 VPWR VGND sg13g2_fill_2
XFILLER_32_18 VPWR VGND sg13g2_decap_8
X_1988_ net198 VGND VPWR _0320_ state\[64\] clknet_leaf_1_clk sg13g2_dfrbpq_1
X_0939_ VPWR _0053_ state\[32\] VGND sg13g2_inv_1
XFILLER_43_203 VPWR VGND sg13g2_decap_8
XFILLER_44_715 VPWR VGND sg13g2_decap_8
Xclkbuf_2_2__f_clk clknet_2_2__leaf_clk clknet_0_clk VPWR VGND sg13g2_buf_16
XFILLER_11_100 VPWR VGND sg13g2_decap_8
XFILLER_12_656 VPWR VGND sg13g2_decap_8
XFILLER_8_605 VPWR VGND sg13g2_decap_8
XFILLER_11_177 VPWR VGND sg13g2_decap_8
XFILLER_22_95 VPWR VGND sg13g2_decap_8
XFILLER_3_354 VPWR VGND sg13g2_decap_8
XFILLER_4_844 VPWR VGND sg13g2_decap_8
XFILLER_7_126 VPWR VGND sg13g2_decap_8
XFILLER_0_0 VPWR VGND sg13g2_decap_8
XFILLER_19_211 VPWR VGND sg13g2_decap_8
Xfanout190 net192 net190 VPWR VGND sg13g2_buf_1
XFILLER_15_450 VPWR VGND sg13g2_decap_4
XFILLER_15_461 VPWR VGND sg13g2_fill_1
XFILLER_34_214 VPWR VGND sg13g2_decap_8
XFILLER_34_269 VPWR VGND sg13g2_decap_8
XFILLER_43_770 VPWR VGND sg13g2_decap_8
XFILLER_47_553 VPWR VGND sg13g2_decap_8
XFILLER_47_70 VPWR VGND sg13g2_decap_8
XFILLER_42_280 VPWR VGND sg13g2_decap_8
XFILLER_8_53 VPWR VGND sg13g2_decap_8
X_1911_ net228 VGND VPWR _0243_ daisychain\[115\] clknet_leaf_6_clk sg13g2_dfrbpq_1
X_1842_ net196 VGND VPWR _0174_ daisychain\[46\] clknet_leaf_14_clk sg13g2_dfrbpq_1
X_1773_ _0627_ VPWR _0361_ VGND net182 _0006_ sg13g2_o21ai_1
XFILLER_38_531 VPWR VGND sg13g2_fill_2
X_1207_ _0140_ _0862_ _0863_ net68 _0713_ VPWR VGND sg13g2_a22oi_1
XFILLER_40_217 VPWR VGND sg13g2_decap_8
XFILLER_43_28 VPWR VGND sg13g2_decap_8
X_1138_ VPWR _0807_ daisychain\[106\] VGND sg13g2_inv_1
X_1069_ VPWR _0738_ daisychain\[37\] VGND sg13g2_inv_1
XFILLER_0_357 VPWR VGND sg13g2_decap_8
XFILLER_1_858 VPWR VGND sg13g2_decap_8
XFILLER_16_203 VPWR VGND sg13g2_decap_8
XFILLER_44_567 VPWR VGND sg13g2_decap_8
XFILLER_12_442 VPWR VGND sg13g2_decap_8
XFILLER_12_464 VPWR VGND sg13g2_fill_1
XFILLER_40_762 VPWR VGND sg13g2_fill_2
XFILLER_8_424 VPWR VGND sg13g2_decap_8
XFILLER_3_151 VPWR VGND sg13g2_decap_8
XFILLER_4_641 VPWR VGND sg13g2_decap_8
XFILLER_47_350 VPWR VGND sg13g2_decap_8
XFILLER_48_862 VPWR VGND sg13g2_decap_8
X_2041_ net228 VGND VPWR _0373_ state\[117\] clknet_leaf_7_clk sg13g2_dfrbpq_1
XFILLER_35_556 VPWR VGND sg13g2_decap_8
XFILLER_35_567 VPWR VGND sg13g2_fill_2
XFILLER_30_261 VPWR VGND sg13g2_fill_2
XFILLER_7_490 VPWR VGND sg13g2_decap_8
Xdigitalen0.g\[2\].u.inv2 VPWR digitalen0.g\[2\].u.OUTP digitalen0.g\[2\].u.OUTN VGND
+ sg13g2_inv_1
X_1825_ net209 VGND VPWR _0157_ daisychain\[29\] clknet_leaf_13_clk sg13g2_dfrbpq_1
X_1756_ _0576_ VPWR _0344_ VGND net167 _0114_ sg13g2_o21ai_1
XFILLER_38_28 VPWR VGND sg13g2_decap_8
X_1687_ _0883_ VPWR _0275_ VGND net175 _0038_ sg13g2_o21ai_1
XFILLER_38_361 VPWR VGND sg13g2_fill_1
XFILLER_38_372 VPWR VGND sg13g2_decap_8
XFILLER_39_895 VPWR VGND sg13g2_decap_8
XFILLER_10_924 VPWR VGND sg13g2_fill_2
XFILLER_41_559 VPWR VGND sg13g2_decap_4
XFILLER_5_438 VPWR VGND sg13g2_decap_8
XFILLER_0_154 VPWR VGND sg13g2_decap_8
XFILLER_1_655 VPWR VGND sg13g2_decap_8
XFILLER_48_147 VPWR VGND sg13g2_decap_8
XFILLER_49_659 VPWR VGND sg13g2_decap_8
XFILLER_17_534 VPWR VGND sg13g2_fill_1
XFILLER_44_364 VPWR VGND sg13g2_decap_8
XFILLER_45_854 VPWR VGND sg13g2_decap_8
XFILLER_12_283 VPWR VGND sg13g2_decap_8
XFILLER_13_773 VPWR VGND sg13g2_fill_2
XFILLER_8_221 VPWR VGND sg13g2_decap_8
XFILLER_8_298 VPWR VGND sg13g2_decap_8
X_1610_ VGND VPWR net97 daisychain\[112\] _0652_ net74 sg13g2_a21oi_1
XFILLER_9_733 VPWR VGND sg13g2_decap_4
XFILLER_5_32 VPWR VGND sg13g2_decap_8
X_1541_ _0797_ net128 _0599_ _0600_ VPWR VGND sg13g2_a21o_1
X_1472_ net156 VPWR _0548_ VGND net113 state\[79\] sg13g2_o21ai_1
XFILLER_36_854 VPWR VGND sg13g2_decap_8
XFILLER_39_147 VPWR VGND sg13g2_decap_8
X_2024_ net215 VGND VPWR _0356_ state\[100\] clknet_leaf_5_clk sg13g2_dfrbpq_1
X_1808_ net221 VGND VPWR _0140_ daisychain\[12\] clknet_leaf_10_clk sg13g2_dfrbpq_1
X_1739_ _0525_ VPWR _0327_ VGND net156 _0096_ sg13g2_o21ai_1
XFILLER_14_515 VPWR VGND sg13g2_decap_8
XFILLER_14_526 VPWR VGND sg13g2_fill_2
XFILLER_41_301 VPWR VGND sg13g2_decap_8
XFILLER_42_813 VPWR VGND sg13g2_decap_8
XFILLER_10_765 VPWR VGND sg13g2_decap_8
XFILLER_10_776 VPWR VGND sg13g2_fill_2
XFILLER_14_96 VPWR VGND sg13g2_decap_8
XFILLER_5_235 VPWR VGND sg13g2_decap_8
XFILLER_6_769 VPWR VGND sg13g2_decap_8
XFILLER_1_452 VPWR VGND sg13g2_decap_8
XFILLER_37_618 VPWR VGND sg13g2_fill_1
XFILLER_45_651 VPWR VGND sg13g2_decap_8
XFILLER_49_478 VPWR VGND sg13g2_decap_8
XFILLER_20_507 VPWR VGND sg13g2_fill_1
XFILLER_32_345 VPWR VGND sg13g2_fill_1
XFILLER_33_857 VPWR VGND sg13g2_decap_8
XFILLER_44_161 VPWR VGND sg13g2_decap_8
X_0972_ VPWR _0089_ state\[65\] VGND sg13g2_inv_1
X_1524_ net172 VPWR _0587_ VGND net127 state\[92\] sg13g2_o21ai_1
X_1455_ _0202_ _0534_ _0535_ net45 _0775_ VPWR VGND sg13g2_a22oi_1
X_1386_ VGND VPWR net81 daisychain\[56\] _0484_ net38 sg13g2_a21oi_1
XFILLER_27_128 VPWR VGND sg13g2_decap_8
XFILLER_35_172 VPWR VGND sg13g2_decap_8
XFILLER_35_18 VPWR VGND sg13g2_decap_8
X_2007_ net211 VGND VPWR _0339_ state\[83\] clknet_leaf_4_clk sg13g2_dfrbpq_1
XFILLER_2_249 VPWR VGND sg13g2_decap_8
XFILLER_3_739 VPWR VGND sg13g2_decap_8
XFILLER_18_139 VPWR VGND sg13g2_decap_8
XFILLER_33_109 VPWR VGND sg13g2_decap_8
XFILLER_46_448 VPWR VGND sg13g2_decap_8
XFILLER_14_334 VPWR VGND sg13g2_decap_4
XFILLER_25_62 VPWR VGND sg13g2_decap_8
XFILLER_26_194 VPWR VGND sg13g2_decap_8
XFILLER_41_175 VPWR VGND sg13g2_decap_8
XFILLER_42_632 VPWR VGND sg13g2_decap_8
XFILLER_10_562 VPWR VGND sg13g2_decap_8
XFILLER_10_573 VPWR VGND sg13g2_fill_2
XFILLER_6_522 VPWR VGND sg13g2_decap_8
XFILLER_6_599 VPWR VGND sg13g2_decap_8
XFILLER_2_11 VPWR VGND sg13g2_decap_8
XFILLER_37_7 VPWR VGND sg13g2_decap_8
XFILLER_38_916 VPWR VGND sg13g2_decap_8
XFILLER_49_242 VPWR VGND sg13g2_decap_8
X_1240_ net175 VPWR _0888_ VGND net131 state\[21\] sg13g2_o21ai_1
X_1171_ _0131_ _0835_ _0836_ net69 _0704_ VPWR VGND sg13g2_a22oi_1
XFILLER_18_684 VPWR VGND sg13g2_decap_8
XFILLER_2_88 VPWR VGND sg13g2_decap_8
XFILLER_20_315 VPWR VGND sg13g2_decap_8
XFILLER_32_186 VPWR VGND sg13g2_decap_8
XFILLER_9_393 VPWR VGND sg13g2_decap_4
X_0955_ VPWR _0070_ state\[48\] VGND sg13g2_inv_1
X_1507_ _0215_ _0573_ _0574_ net57 _0788_ VPWR VGND sg13g2_a22oi_1
XFILLER_46_28 VPWR VGND sg13g2_decap_8
X_1438_ VGND VPWR net83 daisychain\[69\] _0523_ net44 sg13g2_a21oi_1
X_1369_ _0754_ net106 _0470_ _0471_ VPWR VGND sg13g2_a21o_1
XFILLER_23_131 VPWR VGND sg13g2_decap_8
XFILLER_36_492 VPWR VGND sg13g2_decap_8
XFILLER_11_20 VPWR VGND sg13g2_decap_8
XFILLER_3_536 VPWR VGND sg13g2_decap_8
XFILLER_7_308 VPWR VGND sg13g2_decap_8
XFILLER_11_86 VPWR VGND sg13g2_decap_8
XFILLER_2_4 VPWR VGND sg13g2_decap_8
Xdac digitalen3.g\[1\].u.OUTP digitalen3.g\[1\].u.OUTN state\[111\] _0013_ state\[110\]
+ _0012_ state\[109\] _0010_ state\[108\] _0009_ state\[107\] _0008_ state\[106\]
+ _0007_ state\[105\] _0006_ state\[104\] _0005_ state\[103\] _0004_ state\[102\]
+ _0003_ state\[101\] _0002_ state\[100\] _0001_ state\[99\] _0126_ state\[98\] _0125_
+ state\[97\] _0124_ state\[96\] _0123_ digitalen3.g\[0\].u.OUTP digitalen3.g\[0\].u.OUTN
+ digitalen3.g\[3\].u.OUTP digitalen3.g\[3\].u.OUTN state\[127\] _0030_ state\[126\]
+ _0029_ state\[125\] _0028_ state\[124\] _0027_ state\[123\] _0026_ state\[122\]
+ _0025_ state\[121\] _0024_ state\[120\] _0023_ state\[119\] _0021_ state\[118\]
+ _0020_ state\[117\] _0019_ state\[116\] _0018_ state\[115\] _0017_ state\[114\]
+ _0016_ state\[113\] _0015_ state\[112\] _0014_ digitalen3.g\[2\].u.OUTP digitalen3.g\[2\].u.OUTN
+ digitalen2.g\[1\].u.OUTP digitalen2.g\[1\].u.OUTN state\[79\] _0104_ state\[78\]
+ _0103_ state\[77\] _0102_ state\[76\] _0101_ state\[75\] _0100_ state\[74\] _0099_
+ state\[73\] _0098_ state\[72\] _0097_ state\[71\] _0096_ state\[70\] _0095_ state\[69\]
+ _0093_ state\[68\] _0092_ state\[67\] _0091_ state\[66\] _0090_ state\[65\] _0089_
+ state\[64\] _0088_ digitalen2.g\[0\].u.OUTP digitalen2.g\[0\].u.OUTN digitalen2.g\[3\].u.OUTP
+ digitalen2.g\[3\].u.OUTN state\[95\] _0122_ state\[94\] _0121_ state\[93\] _0120_
+ state\[92\] _0119_ state\[91\] _0118_ state\[90\] _0117_ state\[89\] _0115_ state\[88\]
+ _0114_ state\[87\] _0113_ state\[86\] _0112_ state\[85\] _0111_ state\[84\] _0110_
+ state\[83\] _0109_ state\[82\] _0108_ state\[81\] _0107_ state\[80\] _0106_ digitalen2.g\[2\].u.OUTP
+ digitalen2.g\[2\].u.OUTN digitalen1.g\[0\].u.OUTP digitalen1.g\[0\].u.OUTN digitalen1.g\[2\].u.OUTP
+ digitalen1.g\[2\].u.OUTN state\[63\] _0087_ state\[62\] _0086_ state\[61\] _0085_
+ state\[60\] _0084_ state\[59\] _0082_ state\[58\] _0081_ state\[57\] digitalen1.g\[3\].u.OUTP
+ digitalen1.g\[3\].u.OUTN _0080_ state\[56\] _0079_ state\[55\] _0078_ state\[54\]
+ _0077_ state\[53\] _0076_ state\[52\] _0075_ state\[51\] _0074_ state\[50\] _0073_
+ state\[49\] _0071_ state\[48\] _0070_ state\[47\] _0069_ state\[46\] _0068_ state\[45\]
+ _0067_ state\[44\] _0066_ state\[43\] _0065_ state\[42\] _0064_ state\[41\] digitalen1.g\[1\].u.OUTP
+ digitalen1.g\[1\].u.OUTN _0063_ state\[40\] _0062_ state\[39\] _0060_ state\[38\]
+ _0059_ state\[37\] _0058_ state\[36\] _0057_ state\[35\] _0056_ state\[34\] _0055_
+ state\[33\] _0054_ state\[32\] _0053_ digitalen0.g\[0\].u.OUTP digitalen0.g\[0\].u.OUTN
+ digitalen0.g\[2\].u.OUTP digitalen0.g\[2\].u.OUTN state\[31\] _0052_ state\[30\]
+ _0051_ state\[29\] _0049_ state\[28\] _0048_ state\[27\] _0047_ state\[26\] _0046_
+ state\[25\] digitalen0.g\[3\].u.OUTP digitalen0.g\[3\].u.OUTN _0045_ state\[24\]
+ _0044_ state\[23\] _0043_ state\[22\] _0042_ state\[21\] _0041_ state\[20\] _0040_
+ state\[19\] _0038_ state\[18\] _0037_ state\[17\] _0036_ state\[16\] _0035_ state\[15\]
+ _0034_ state\[14\] _0033_ state\[13\] _0032_ state\[12\] _0031_ state\[11\] _0022_
+ state\[10\] _0011_ state\[9\] digitalen0.g\[1\].u.OUTP digitalen0.g\[1\].u.OUTN
+ _0127_ state\[8\] _0116_ state\[7\] _0105_ state\[6\] _0094_ state\[5\] _0083_ state\[4\]
+ _0072_ state\[3\] _0061_ state\[2\] _0050_ state\[1\] _0039_ state\[0\] _0000_ VPWR
+ VGND dac/VbiasP[0] dac/VbiasP[1] dac/VbiasP[2] dac/VbiasP[3] dac/VbiasP[4] dac/VbiasP[5]
+ dac/VbiasP[6] dac/VbiasP[7] i_out dac4x32module
XFILLER_14_131 VPWR VGND sg13g2_decap_8
XFILLER_19_426 VPWR VGND sg13g2_decap_8
XFILLER_46_245 VPWR VGND sg13g2_decap_8
XFILLER_47_735 VPWR VGND sg13g2_decap_8
XFILLER_30_679 VPWR VGND sg13g2_fill_2
XFILLER_42_495 VPWR VGND sg13g2_decap_8
XFILLER_35_4 VPWR VGND sg13g2_decap_8
XFILLER_6_396 VPWR VGND sg13g2_decap_8
XFILLER_37_245 VPWR VGND sg13g2_decap_8
X_1223_ _0144_ _0874_ _0875_ net66 _0717_ VPWR VGND sg13g2_a22oi_1
X_1154_ VPWR _0823_ daisychain\[122\] VGND sg13g2_inv_1
XFILLER_33_440 VPWR VGND sg13g2_decap_4
X_1085_ VPWR _0754_ daisychain\[53\] VGND sg13g2_inv_1
XFILLER_20_167 VPWR VGND sg13g2_decap_8
X_1987_ net193 VGND VPWR _0319_ state\[63\] clknet_leaf_1_clk sg13g2_dfrbpq_1
X_0938_ VPWR _0052_ state\[31\] VGND sg13g2_inv_1
XFILLER_0_539 VPWR VGND sg13g2_decap_8
XFILLER_28_267 VPWR VGND sg13g2_decap_8
XFILLER_37_790 VPWR VGND sg13g2_decap_4
XFILLER_43_259 VPWR VGND sg13g2_decap_8
XFILLER_11_156 VPWR VGND sg13g2_decap_8
XFILLER_12_613 VPWR VGND sg13g2_decap_8
XFILLER_7_105 VPWR VGND sg13g2_decap_8
XFILLER_20_690 VPWR VGND sg13g2_decap_8
XFILLER_22_74 VPWR VGND sg13g2_decap_8
XFILLER_3_333 VPWR VGND sg13g2_decap_8
XFILLER_4_823 VPWR VGND sg13g2_decap_8
XFILLER_47_532 VPWR VGND sg13g2_decap_8
Xfanout180 net181 net180 VPWR VGND sg13g2_buf_1
Xfanout191 net192 net191 VPWR VGND sg13g2_buf_1
XFILLER_19_267 VPWR VGND sg13g2_decap_4
XFILLER_34_248 VPWR VGND sg13g2_decap_8
XFILLER_34_259 VPWR VGND sg13g2_decap_4
XFILLER_35_738 VPWR VGND sg13g2_decap_4
X_1910_ net228 VGND VPWR _0242_ daisychain\[114\] clknet_leaf_6_clk sg13g2_dfrbpq_1
XFILLER_7_683 VPWR VGND sg13g2_fill_1
XFILLER_8_32 VPWR VGND sg13g2_decap_8
X_1841_ net195 VGND VPWR _0173_ daisychain\[45\] clknet_leaf_15_clk sg13g2_dfrbpq_1
X_1772_ _0624_ VPWR _0360_ VGND net184 _0005_ sg13g2_o21ai_1
XFILLER_6_193 VPWR VGND sg13g2_decap_8
XFILLER_38_554 VPWR VGND sg13g2_fill_2
X_1206_ VGND VPWR net93 daisychain\[11\] _0863_ net68 sg13g2_a21oi_1
X_1137_ VPWR _0806_ daisychain\[105\] VGND sg13g2_inv_1
X_1068_ VPWR _0737_ daisychain\[36\] VGND sg13g2_inv_1
XFILLER_0_336 VPWR VGND sg13g2_decap_8
XFILLER_1_837 VPWR VGND sg13g2_decap_8
XFILLER_48_329 VPWR VGND sg13g2_decap_8
XFILLER_16_259 VPWR VGND sg13g2_decap_4
XFILLER_24_270 VPWR VGND sg13g2_decap_8
XFILLER_31_207 VPWR VGND sg13g2_fill_1
XFILLER_32_719 VPWR VGND sg13g2_decap_4
XFILLER_40_730 VPWR VGND sg13g2_decap_4
XFILLER_44_546 VPWR VGND sg13g2_decap_8
XFILLER_12_476 VPWR VGND sg13g2_fill_1
XFILLER_12_487 VPWR VGND sg13g2_decap_8
XFILLER_33_95 VPWR VGND sg13g2_decap_8
XFILLER_8_403 VPWR VGND sg13g2_decap_8
XFILLER_9_926 VPWR VGND sg13g2_fill_1
XFILLER_3_130 VPWR VGND sg13g2_decap_8
XFILLER_4_620 VPWR VGND sg13g2_decap_8
XFILLER_4_697 VPWR VGND sg13g2_decap_8
XFILLER_35_502 VPWR VGND sg13g2_decap_4
XFILLER_39_329 VPWR VGND sg13g2_decap_8
XFILLER_48_841 VPWR VGND sg13g2_decap_8
X_2040_ net228 VGND VPWR _0372_ state\[116\] clknet_leaf_7_clk sg13g2_dfrbpq_1
XFILLER_15_292 VPWR VGND sg13g2_decap_8
XFILLER_22_229 VPWR VGND sg13g2_fill_1
XFILLER_30_251 VPWR VGND sg13g2_fill_1
X_1824_ net208 VGND VPWR _0156_ daisychain\[28\] clknet_leaf_11_clk sg13g2_dfrbpq_1
X_1755_ _0573_ VPWR _0343_ VGND net167 _0113_ sg13g2_o21ai_1
X_1686_ _0880_ VPWR _0274_ VGND net181 _0037_ sg13g2_o21ai_1
XFILLER_39_874 VPWR VGND sg13g2_decap_8
XFILLER_5_417 VPWR VGND sg13g2_decap_8
XFILLER_0_133 VPWR VGND sg13g2_decap_8
XFILLER_1_634 VPWR VGND sg13g2_decap_8
XFILLER_28_84 VPWR VGND sg13g2_decap_8
XFILLER_45_833 VPWR VGND sg13g2_decap_8
XFILLER_48_126 VPWR VGND sg13g2_decap_8
XFILLER_49_638 VPWR VGND sg13g2_decap_8
XFILLER_12_262 VPWR VGND sg13g2_decap_8
XFILLER_44_343 VPWR VGND sg13g2_decap_8
XFILLER_8_200 VPWR VGND sg13g2_decap_8
XFILLER_40_582 VPWR VGND sg13g2_fill_2
XFILLER_5_11 VPWR VGND sg13g2_decap_8
XFILLER_8_277 VPWR VGND sg13g2_decap_8
X_1540_ net173 VPWR _0599_ VGND net128 state\[96\] sg13g2_o21ai_1
XFILLER_39_126 VPWR VGND sg13g2_decap_8
XFILLER_4_494 VPWR VGND sg13g2_decap_8
XFILLER_5_88 VPWR VGND sg13g2_decap_8
X_1471_ _0206_ _0546_ _0547_ net46 _0779_ VPWR VGND sg13g2_a22oi_1
XFILLER_35_343 VPWR VGND sg13g2_fill_1
XFILLER_48_693 VPWR VGND sg13g2_decap_8
X_2023_ net214 VGND VPWR _0355_ state\[99\] clknet_leaf_5_clk sg13g2_dfrbpq_1
X_1807_ net218 VGND VPWR _0139_ daisychain\[11\] clknet_leaf_11_clk sg13g2_dfrbpq_1
XFILLER_49_39 VPWR VGND sg13g2_decap_8
X_1738_ _0522_ VPWR _0326_ VGND net154 _0095_ sg13g2_o21ai_1
X_1669_ _0829_ VPWR _0257_ VGND net180 _0039_ sg13g2_o21ai_1
XFILLER_39_682 VPWR VGND sg13g2_decap_8
XFILLER_14_20 VPWR VGND sg13g2_fill_1
XFILLER_41_379 VPWR VGND sg13g2_fill_2
XFILLER_42_869 VPWR VGND sg13g2_decap_8
XFILLER_14_75 VPWR VGND sg13g2_fill_1
XFILLER_5_214 VPWR VGND sg13g2_decap_8
XFILLER_6_748 VPWR VGND sg13g2_decap_8
XFILLER_1_431 VPWR VGND sg13g2_decap_8
XFILLER_2_921 VPWR VGND sg13g2_decap_4
XFILLER_30_85 VPWR VGND sg13g2_decap_8
XFILLER_49_457 VPWR VGND sg13g2_decap_8
XFILLER_17_310 VPWR VGND sg13g2_decap_8
XFILLER_18_855 VPWR VGND sg13g2_decap_4
XFILLER_29_181 VPWR VGND sg13g2_decap_8
XFILLER_44_140 VPWR VGND sg13g2_decap_8
XFILLER_45_630 VPWR VGND sg13g2_decap_8
XFILLER_13_593 VPWR VGND sg13g2_fill_1
XFILLER_32_335 VPWR VGND sg13g2_fill_2
X_0971_ VPWR _0088_ state\[64\] VGND sg13g2_inv_1
XFILLER_4_291 VPWR VGND sg13g2_decap_8
XFILLER_5_781 VPWR VGND sg13g2_decap_8
X_1523_ _0219_ _0585_ _0586_ net59 _0792_ VPWR VGND sg13g2_a22oi_1
X_1454_ VGND VPWR net83 daisychain\[73\] _0535_ net44 sg13g2_a21oi_1
XFILLER_27_107 VPWR VGND sg13g2_decap_8
XFILLER_48_490 VPWR VGND sg13g2_decap_8
X_1385_ _0758_ net105 _0482_ _0483_ VPWR VGND sg13g2_a21o_1
XFILLER_11_519 VPWR VGND sg13g2_fill_1
XFILLER_35_151 VPWR VGND sg13g2_decap_8
XFILLER_36_685 VPWR VGND sg13g2_decap_8
X_2006_ net213 VGND VPWR _0338_ state\[82\] clknet_leaf_3_clk sg13g2_dfrbpq_1
XFILLER_3_718 VPWR VGND sg13g2_decap_8
XFILLER_2_228 VPWR VGND sg13g2_decap_8
XFILLER_14_313 VPWR VGND sg13g2_decap_8
XFILLER_18_118 VPWR VGND sg13g2_decap_8
XFILLER_26_173 VPWR VGND sg13g2_decap_8
XFILLER_46_427 VPWR VGND sg13g2_decap_8
XFILLER_47_917 VPWR VGND sg13g2_decap_8
XFILLER_10_530 VPWR VGND sg13g2_decap_4
XFILLER_25_41 VPWR VGND sg13g2_decap_8
XFILLER_41_154 VPWR VGND sg13g2_decap_8
XFILLER_42_644 VPWR VGND sg13g2_decap_8
XFILLER_42_655 VPWR VGND sg13g2_fill_2
XFILLER_6_501 VPWR VGND sg13g2_decap_8
XFILLER_41_84 VPWR VGND sg13g2_decap_8
XFILLER_6_578 VPWR VGND sg13g2_decap_8
XFILLER_1_294 VPWR VGND sg13g2_decap_8
XFILLER_2_67 VPWR VGND sg13g2_decap_8
XFILLER_2_795 VPWR VGND sg13g2_decap_8
XFILLER_49_221 VPWR VGND sg13g2_decap_8
XFILLER_49_298 VPWR VGND sg13g2_decap_8
X_1170_ VGND VPWR net93 daisychain\[2\] _0836_ net67 sg13g2_a21oi_1
XFILLER_17_195 VPWR VGND sg13g2_decap_8
XFILLER_18_663 VPWR VGND sg13g2_fill_2
XFILLER_32_165 VPWR VGND sg13g2_decap_8
XFILLER_33_611 VPWR VGND sg13g2_fill_2
XFILLER_33_655 VPWR VGND sg13g2_decap_8
XFILLER_33_677 VPWR VGND sg13g2_decap_4
X_0954_ VPWR _0069_ state\[47\] VGND sg13g2_inv_1
X_1506_ VGND VPWR net90 daisychain\[86\] _0574_ net57 sg13g2_a21oi_1
X_1437_ _0771_ net110 _0521_ _0522_ VPWR VGND sg13g2_a21o_1
X_1368_ net150 VPWR _0470_ VGND net106 state\[53\] sg13g2_o21ai_1
X_1299_ _0163_ _0417_ _0418_ net52 _0736_ VPWR VGND sg13g2_a22oi_1
XFILLER_11_338 VPWR VGND sg13g2_decap_8
XFILLER_11_349 VPWR VGND sg13g2_fill_1
XFILLER_12_817 VPWR VGND sg13g2_fill_1
XFILLER_23_110 VPWR VGND sg13g2_decap_8
XFILLER_23_187 VPWR VGND sg13g2_decap_8
XFILLER_11_65 VPWR VGND sg13g2_fill_2
XFILLER_3_515 VPWR VGND sg13g2_decap_8
XFILLER_46_224 VPWR VGND sg13g2_decap_8
XFILLER_47_714 VPWR VGND sg13g2_decap_8
XFILLER_14_110 VPWR VGND sg13g2_decap_8
XFILLER_36_95 VPWR VGND sg13g2_decap_8
XFILLER_42_441 VPWR VGND sg13g2_decap_8
XFILLER_14_187 VPWR VGND sg13g2_decap_8
XFILLER_30_669 VPWR VGND sg13g2_decap_4
XFILLER_42_474 VPWR VGND sg13g2_decap_8
XFILLER_2_592 VPWR VGND sg13g2_decap_8
XFILLER_6_375 VPWR VGND sg13g2_decap_8
XFILLER_18_471 VPWR VGND sg13g2_decap_4
XFILLER_28_4 VPWR VGND sg13g2_decap_8
XFILLER_37_224 VPWR VGND sg13g2_decap_8
X_1222_ VGND VPWR net95 daisychain\[15\] _0875_ net66 sg13g2_a21oi_1
X_1153_ VPWR _0822_ daisychain\[121\] VGND sg13g2_inv_1
X_1084_ VPWR _0753_ daisychain\[52\] VGND sg13g2_inv_1
XFILLER_18_493 VPWR VGND sg13g2_decap_8
XFILLER_20_146 VPWR VGND sg13g2_decap_8
XFILLER_46_791 VPWR VGND sg13g2_decap_8
X_1986_ net191 VGND VPWR _0318_ state\[62\] clknet_leaf_0_clk sg13g2_dfrbpq_1
Xclkbuf_leaf_9_clk clknet_2_2__leaf_clk clknet_leaf_9_clk VPWR VGND sg13g2_buf_8
X_0937_ VPWR _0051_ state\[30\] VGND sg13g2_inv_1
XFILLER_0_518 VPWR VGND sg13g2_decap_8
XFILLER_28_257 VPWR VGND sg13g2_decap_4
XFILLER_43_238 VPWR VGND sg13g2_decap_8
XFILLER_11_135 VPWR VGND sg13g2_decap_8
XFILLER_12_636 VPWR VGND sg13g2_decap_8
XFILLER_22_53 VPWR VGND sg13g2_decap_8
XFILLER_4_802 VPWR VGND sg13g2_decap_8
XFILLER_3_312 VPWR VGND sg13g2_decap_8
XFILLER_3_389 VPWR VGND sg13g2_decap_8
XFILLER_4_879 VPWR VGND sg13g2_decap_8
XFILLER_47_511 VPWR VGND sg13g2_decap_8
XFILLER_47_588 VPWR VGND sg13g2_decap_8
Xfanout170 net189 net170 VPWR VGND sg13g2_buf_1
Xfanout181 net189 net181 VPWR VGND sg13g2_buf_1
Xfanout192 net1 net192 VPWR VGND sg13g2_buf_1
XFILLER_16_920 VPWR VGND sg13g2_decap_8
XFILLER_8_11 VPWR VGND sg13g2_decap_8
X_1840_ net195 VGND VPWR _0172_ daisychain\[44\] clknet_leaf_15_clk sg13g2_dfrbpq_1
XFILLER_10_190 VPWR VGND sg13g2_decap_8
XFILLER_30_477 VPWR VGND sg13g2_decap_8
XFILLER_6_172 VPWR VGND sg13g2_decap_8
XFILLER_8_88 VPWR VGND sg13g2_decap_8
X_1771_ _0621_ VPWR _0359_ VGND net184 _0004_ sg13g2_o21ai_1
XFILLER_25_216 VPWR VGND sg13g2_decap_8
XFILLER_38_533 VPWR VGND sg13g2_fill_1
XFILLER_38_599 VPWR VGND sg13g2_decap_8
X_1205_ _0713_ net134 _0861_ _0862_ VPWR VGND sg13g2_a21o_1
X_1136_ VPWR _0805_ daisychain\[104\] VGND sg13g2_inv_1
X_1067_ VPWR _0736_ daisychain\[35\] VGND sg13g2_inv_1
X_1969_ net204 VGND VPWR _0301_ state\[45\] clknet_leaf_13_clk sg13g2_dfrbpq_1
XFILLER_0_315 VPWR VGND sg13g2_decap_8
XFILLER_1_816 VPWR VGND sg13g2_fill_1
XFILLER_4_109 VPWR VGND sg13g2_decap_8
XFILLER_17_31 VPWR VGND sg13g2_fill_1
XFILLER_48_308 VPWR VGND sg13g2_decap_8
XFILLER_49_809 VPWR VGND sg13g2_decap_4
XFILLER_16_238 VPWR VGND sg13g2_decap_8
XFILLER_17_97 VPWR VGND sg13g2_decap_8
XFILLER_40_753 VPWR VGND sg13g2_decap_4
XFILLER_44_525 VPWR VGND sg13g2_decap_8
XFILLER_33_74 VPWR VGND sg13g2_decap_8
XFILLER_8_459 VPWR VGND sg13g2_decap_8
XFILLER_39_308 VPWR VGND sg13g2_decap_8
XFILLER_3_186 VPWR VGND sg13g2_decap_8
XFILLER_48_820 VPWR VGND sg13g2_decap_8
XFILLER_4_676 VPWR VGND sg13g2_decap_8
XFILLER_16_750 VPWR VGND sg13g2_decap_4
XFILLER_47_385 VPWR VGND sg13g2_decap_8
XFILLER_48_897 VPWR VGND sg13g2_decap_8
XFILLER_15_271 VPWR VGND sg13g2_decap_8
XFILLER_31_764 VPWR VGND sg13g2_decap_8
X_1823_ net207 VGND VPWR _0155_ daisychain\[27\] clknet_leaf_11_clk sg13g2_dfrbpq_1
X_1754_ _0570_ VPWR _0342_ VGND net169 _0112_ sg13g2_o21ai_1
X_1685_ _0877_ VPWR _0273_ VGND net176 _0036_ sg13g2_o21ai_1
XFILLER_13_219 VPWR VGND sg13g2_decap_8
XFILLER_38_396 VPWR VGND sg13g2_decap_8
X_1119_ VPWR _0788_ daisychain\[87\] VGND sg13g2_inv_1
XFILLER_10_926 VPWR VGND sg13g2_fill_1
XFILLER_0_112 VPWR VGND sg13g2_decap_8
XFILLER_1_613 VPWR VGND sg13g2_decap_8
XFILLER_48_105 VPWR VGND sg13g2_decap_8
XFILLER_49_617 VPWR VGND sg13g2_decap_8
XFILLER_0_189 VPWR VGND sg13g2_decap_8
XFILLER_17_525 VPWR VGND sg13g2_decap_4
XFILLER_44_322 VPWR VGND sg13g2_decap_8
XFILLER_45_812 VPWR VGND sg13g2_decap_8
XFILLER_45_889 VPWR VGND sg13g2_decap_8
XFILLER_12_241 VPWR VGND sg13g2_decap_8
XFILLER_13_775 VPWR VGND sg13g2_fill_1
XFILLER_44_399 VPWR VGND sg13g2_decap_8
XFILLER_44_84 VPWR VGND sg13g2_decap_8
XFILLER_9_702 VPWR VGND sg13g2_decap_8
XFILLER_4_473 VPWR VGND sg13g2_decap_8
XFILLER_5_67 VPWR VGND sg13g2_decap_8
XFILLER_8_256 VPWR VGND sg13g2_decap_8
X_1470_ VGND VPWR net82 daisychain\[77\] _0547_ net46 sg13g2_a21oi_1
XFILLER_39_105 VPWR VGND sg13g2_decap_8
XFILLER_48_672 VPWR VGND sg13g2_decap_8
XFILLER_36_878 VPWR VGND sg13g2_decap_8
XFILLER_47_182 VPWR VGND sg13g2_decap_8
X_2022_ net214 VGND VPWR _0354_ state\[98\] clknet_leaf_5_clk sg13g2_dfrbpq_1
XFILLER_31_594 VPWR VGND sg13g2_decap_4
X_1806_ net218 VGND VPWR _0138_ daisychain\[10\] clknet_leaf_11_clk sg13g2_dfrbpq_1
XFILLER_49_18 VPWR VGND sg13g2_decap_8
X_1737_ _0519_ VPWR _0325_ VGND net154 _0093_ sg13g2_o21ai_1
X_1668_ _0825_ VPWR _0256_ VGND net180 _0000_ sg13g2_o21ai_1
X_1599_ _0238_ _0642_ _0643_ net71 _0811_ VPWR VGND sg13g2_a22oi_1
XFILLER_38_182 VPWR VGND sg13g2_decap_8
XFILLER_45_119 VPWR VGND sg13g2_decap_8
XFILLER_46_609 VPWR VGND sg13g2_decap_8
XFILLER_10_745 VPWR VGND sg13g2_decap_4
XFILLER_41_336 VPWR VGND sg13g2_decap_8
XFILLER_41_358 VPWR VGND sg13g2_decap_8
XFILLER_42_848 VPWR VGND sg13g2_decap_8
XFILLER_1_410 VPWR VGND sg13g2_decap_8
XFILLER_2_900 VPWR VGND sg13g2_decap_8
XFILLER_30_64 VPWR VGND sg13g2_decap_8
XFILLER_6_716 VPWR VGND sg13g2_decap_8
XFILLER_6_727 VPWR VGND sg13g2_decap_8
XFILLER_1_487 VPWR VGND sg13g2_decap_8
XFILLER_37_609 VPWR VGND sg13g2_decap_8
XFILLER_39_84 VPWR VGND sg13g2_decap_8
XFILLER_49_436 VPWR VGND sg13g2_decap_8
XFILLER_17_399 VPWR VGND sg13g2_decap_4
XFILLER_18_834 VPWR VGND sg13g2_decap_8
XFILLER_29_160 VPWR VGND sg13g2_decap_8
XFILLER_33_826 VPWR VGND sg13g2_decap_8
XFILLER_44_196 VPWR VGND sg13g2_decap_8
XFILLER_45_686 VPWR VGND sg13g2_decap_8
XFILLER_13_572 VPWR VGND sg13g2_fill_2
XFILLER_41_892 VPWR VGND sg13g2_decap_8
X_0970_ VPWR _0087_ state\[63\] VGND sg13g2_inv_1
XFILLER_9_565 VPWR VGND sg13g2_fill_2
XFILLER_9_554 VPWR VGND sg13g2_decap_8
XFILLER_4_270 VPWR VGND sg13g2_decap_8
XFILLER_5_760 VPWR VGND sg13g2_decap_8
X_1522_ VGND VPWR net88 daisychain\[90\] _0586_ net59 sg13g2_a21oi_1
X_1453_ _0775_ net111 _0533_ _0534_ VPWR VGND sg13g2_a21o_1
XFILLER_35_130 VPWR VGND sg13g2_decap_8
XFILLER_36_620 VPWR VGND sg13g2_fill_2
X_2005_ net213 VGND VPWR _0337_ state\[81\] clknet_leaf_3_clk sg13g2_dfrbpq_1
X_1384_ net149 VPWR _0482_ VGND net104 state\[57\] sg13g2_o21ai_1
XFILLER_2_207 VPWR VGND sg13g2_decap_8
XFILLER_46_406 VPWR VGND sg13g2_decap_8
XFILLER_15_848 VPWR VGND sg13g2_decap_8
XFILLER_25_20 VPWR VGND sg13g2_decap_8
XFILLER_26_152 VPWR VGND sg13g2_decap_8
XFILLER_42_623 VPWR VGND sg13g2_decap_4
XFILLER_25_97 VPWR VGND sg13g2_decap_8
XFILLER_41_133 VPWR VGND sg13g2_decap_8
XFILLER_41_63 VPWR VGND sg13g2_decap_8
XFILLER_2_774 VPWR VGND sg13g2_decap_8
XFILLER_6_557 VPWR VGND sg13g2_decap_8
XFILLER_1_273 VPWR VGND sg13g2_decap_8
XFILLER_2_46 VPWR VGND sg13g2_decap_8
XFILLER_49_200 VPWR VGND sg13g2_decap_8
XFILLER_49_277 VPWR VGND sg13g2_decap_8
XFILLER_17_174 VPWR VGND sg13g2_decap_8
XFILLER_32_144 VPWR VGND sg13g2_decap_8
XFILLER_45_483 VPWR VGND sg13g2_decap_8
XFILLER_13_380 VPWR VGND sg13g2_fill_1
XFILLER_9_340 VPWR VGND sg13g2_decap_8
X_0953_ VPWR _0068_ state\[46\] VGND sg13g2_inv_1
X_1505_ _0788_ net123 _0572_ _0573_ VPWR VGND sg13g2_a21o_1
X_1436_ net154 VPWR _0521_ VGND net110 state\[70\] sg13g2_o21ai_1
X_1367_ _0180_ _0468_ _0469_ net41 _0753_ VPWR VGND sg13g2_a22oi_1
X_1298_ VGND VPWR net85 daisychain\[34\] _0418_ net52 sg13g2_a21oi_1
XFILLER_11_317 VPWR VGND sg13g2_decap_8
XFILLER_23_166 VPWR VGND sg13g2_decap_8
XFILLER_11_55 VPWR VGND sg13g2_decap_8
XFILLER_46_203 VPWR VGND sg13g2_decap_8
XFILLER_14_166 VPWR VGND sg13g2_decap_8
XFILLER_15_678 VPWR VGND sg13g2_decap_8
XFILLER_15_689 VPWR VGND sg13g2_fill_2
XFILLER_36_74 VPWR VGND sg13g2_decap_8
XFILLER_42_420 VPWR VGND sg13g2_decap_8
XFILLER_43_910 VPWR VGND sg13g2_decap_8
XFILLER_10_361 VPWR VGND sg13g2_fill_1
XFILLER_11_895 VPWR VGND sg13g2_fill_1
XFILLER_30_648 VPWR VGND sg13g2_fill_2
XFILLER_6_354 VPWR VGND sg13g2_decap_8
XFILLER_7_833 VPWR VGND sg13g2_fill_2
XFILLER_2_571 VPWR VGND sg13g2_decap_8
XFILLER_42_7 VPWR VGND sg13g2_decap_8
X_1221_ _0717_ net132 _0873_ _0874_ VPWR VGND sg13g2_a21o_1
XFILLER_33_420 VPWR VGND sg13g2_fill_1
XFILLER_34_910 VPWR VGND sg13g2_decap_8
XFILLER_37_203 VPWR VGND sg13g2_decap_8
XFILLER_38_726 VPWR VGND sg13g2_fill_2
XFILLER_45_280 VPWR VGND sg13g2_decap_8
XFILLER_46_770 VPWR VGND sg13g2_decap_8
X_1152_ VPWR _0821_ daisychain\[120\] VGND sg13g2_inv_1
X_1083_ VPWR _0752_ daisychain\[51\] VGND sg13g2_inv_1
XFILLER_20_125 VPWR VGND sg13g2_decap_8
X_1985_ net193 VGND VPWR _0317_ state\[61\] clknet_leaf_0_clk sg13g2_dfrbpq_1
X_0936_ VPWR _0049_ state\[29\] VGND sg13g2_inv_1
XFILLER_28_203 VPWR VGND sg13g2_decap_4
X_1419_ _0193_ _0507_ _0508_ net37 _0766_ VPWR VGND sg13g2_a22oi_1
XFILLER_11_114 VPWR VGND sg13g2_decap_8
XFILLER_36_291 VPWR VGND sg13g2_decap_8
XFILLER_40_913 VPWR VGND sg13g2_decap_8
XFILLER_43_217 VPWR VGND sg13g2_decap_8
XFILLER_44_729 VPWR VGND sg13g2_decap_8
XFILLER_22_32 VPWR VGND sg13g2_decap_8
XFILLER_3_368 VPWR VGND sg13g2_decap_8
XFILLER_4_858 VPWR VGND sg13g2_decap_8
XFILLER_19_225 VPWR VGND sg13g2_decap_4
XFILLER_19_236 VPWR VGND sg13g2_fill_1
XFILLER_34_228 VPWR VGND sg13g2_decap_8
XFILLER_47_567 VPWR VGND sg13g2_decap_8
XFILLER_47_84 VPWR VGND sg13g2_decap_8
Xfanout160 net162 net160 VPWR VGND sg13g2_buf_1
Xfanout171 net172 net171 VPWR VGND sg13g2_buf_1
Xfanout182 net188 net182 VPWR VGND sg13g2_buf_1
Xfanout193 net194 net193 VPWR VGND sg13g2_buf_1
XFILLER_30_434 VPWR VGND sg13g2_decap_8
XFILLER_42_294 VPWR VGND sg13g2_decap_8
XFILLER_43_784 VPWR VGND sg13g2_decap_8
XFILLER_8_67 VPWR VGND sg13g2_decap_8
X_1770_ _0618_ VPWR _0358_ VGND net173 _0003_ sg13g2_o21ai_1
XFILLER_11_681 VPWR VGND sg13g2_fill_2
XFILLER_6_151 VPWR VGND sg13g2_decap_8
XFILLER_7_663 VPWR VGND sg13g2_fill_2
XFILLER_38_556 VPWR VGND sg13g2_fill_1
X_1204_ net177 VPWR _0861_ VGND net134 state\[12\] sg13g2_o21ai_1
XFILLER_19_770 VPWR VGND sg13g2_fill_1
X_1135_ VPWR _0804_ daisychain\[103\] VGND sg13g2_inv_1
X_1066_ VPWR _0735_ daisychain\[34\] VGND sg13g2_inv_1
X_1968_ net204 VGND VPWR _0300_ state\[44\] clknet_leaf_12_clk sg13g2_dfrbpq_1
X_1899_ net225 VGND VPWR _0231_ daisychain\[103\] clknet_leaf_6_clk sg13g2_dfrbpq_1
X_0919_ VPWR _0031_ state\[12\] VGND sg13g2_inv_1
XFILLER_16_217 VPWR VGND sg13g2_decap_8
XFILLER_44_504 VPWR VGND sg13g2_decap_8
XFILLER_12_456 VPWR VGND sg13g2_fill_2
XFILLER_17_76 VPWR VGND sg13g2_decap_8
XFILLER_33_53 VPWR VGND sg13g2_decap_8
XFILLER_40_776 VPWR VGND sg13g2_decap_8
XFILLER_4_655 VPWR VGND sg13g2_decap_8
XFILLER_8_438 VPWR VGND sg13g2_decap_8
XFILLER_0_883 VPWR VGND sg13g2_decap_8
XFILLER_3_165 VPWR VGND sg13g2_decap_8
XFILLER_15_250 VPWR VGND sg13g2_decap_8
XFILLER_35_548 VPWR VGND sg13g2_decap_4
XFILLER_47_364 VPWR VGND sg13g2_decap_8
XFILLER_48_876 VPWR VGND sg13g2_decap_8
XFILLER_30_242 VPWR VGND sg13g2_decap_8
XFILLER_43_581 VPWR VGND sg13g2_decap_8
X_1822_ net207 VGND VPWR _0154_ daisychain\[26\] clknet_leaf_11_clk sg13g2_dfrbpq_1
X_1753_ _0567_ VPWR _0341_ VGND net169 _0111_ sg13g2_o21ai_1
X_1684_ _0874_ VPWR _0272_ VGND net176 _0035_ sg13g2_o21ai_1
XFILLER_38_386 VPWR VGND sg13g2_decap_8
X_1118_ VPWR _0787_ daisychain\[86\] VGND sg13g2_inv_1
X_1049_ VPWR _0718_ daisychain\[17\] VGND sg13g2_inv_1
XFILLER_6_909 VPWR VGND sg13g2_decap_8
XFILLER_0_168 VPWR VGND sg13g2_decap_8
XFILLER_1_669 VPWR VGND sg13g2_decap_8
XFILLER_28_53 VPWR VGND sg13g2_decap_4
XFILLER_44_301 VPWR VGND sg13g2_decap_8
XFILLER_44_378 VPWR VGND sg13g2_decap_8
XFILLER_45_868 VPWR VGND sg13g2_decap_8
XFILLER_12_220 VPWR VGND sg13g2_decap_8
XFILLER_12_297 VPWR VGND sg13g2_decap_8
XFILLER_40_584 VPWR VGND sg13g2_fill_1
XFILLER_44_63 VPWR VGND sg13g2_decap_8
XFILLER_8_235 VPWR VGND sg13g2_decap_8
XFILLER_4_452 VPWR VGND sg13g2_decap_8
XFILLER_5_46 VPWR VGND sg13g2_decap_8
XFILLER_0_680 VPWR VGND sg13g2_decap_8
XFILLER_36_846 VPWR VGND sg13g2_fill_1
XFILLER_47_161 VPWR VGND sg13g2_decap_8
XFILLER_48_651 VPWR VGND sg13g2_decap_8
X_2021_ net214 VGND VPWR _0353_ state\[97\] clknet_leaf_4_clk sg13g2_dfrbpq_1
XFILLER_35_378 VPWR VGND sg13g2_fill_1
XFILLER_44_890 VPWR VGND sg13g2_decap_8
XFILLER_8_780 VPWR VGND sg13g2_decap_8
X_1805_ net218 VGND VPWR _0137_ daisychain\[9\] clknet_leaf_11_clk sg13g2_dfrbpq_1
X_1736_ _0516_ VPWR _0324_ VGND net153 _0092_ sg13g2_o21ai_1
X_1667_ _0255_ _0693_ _0694_ net35 _0700_ VPWR VGND sg13g2_a22oi_1
X_1598_ VGND VPWR net96 daisychain\[109\] _0643_ net71 sg13g2_a21oi_1
XFILLER_38_161 VPWR VGND sg13g2_decap_8
XFILLER_39_662 VPWR VGND sg13g2_decap_4
XFILLER_41_315 VPWR VGND sg13g2_decap_8
XFILLER_42_827 VPWR VGND sg13g2_decap_8
XFILLER_10_735 VPWR VGND sg13g2_fill_1
XFILLER_30_32 VPWR VGND sg13g2_decap_8
XFILLER_30_43 VPWR VGND sg13g2_decap_8
XFILLER_5_249 VPWR VGND sg13g2_decap_8
XFILLER_18_813 VPWR VGND sg13g2_decap_8
XFILLER_1_466 VPWR VGND sg13g2_decap_8
XFILLER_36_109 VPWR VGND sg13g2_decap_8
XFILLER_39_63 VPWR VGND sg13g2_decap_8
XFILLER_49_415 VPWR VGND sg13g2_decap_8
XFILLER_32_304 VPWR VGND sg13g2_decap_8
XFILLER_32_315 VPWR VGND sg13g2_fill_1
XFILLER_32_337 VPWR VGND sg13g2_fill_1
XFILLER_33_849 VPWR VGND sg13g2_fill_2
XFILLER_41_871 VPWR VGND sg13g2_decap_8
XFILLER_44_175 VPWR VGND sg13g2_decap_8
XFILLER_45_665 VPWR VGND sg13g2_decap_8
X_1521_ _0792_ net127 _0584_ _0585_ VPWR VGND sg13g2_a21o_1
X_1452_ net155 VPWR _0533_ VGND net111 state\[74\] sg13g2_o21ai_1
X_1383_ _0184_ _0480_ _0481_ net38 _0757_ VPWR VGND sg13g2_a22oi_1
X_2004_ net213 VGND VPWR _0336_ state\[80\] clknet_leaf_3_clk sg13g2_dfrbpq_1
XFILLER_31_381 VPWR VGND sg13g2_decap_8
XFILLER_32_882 VPWR VGND sg13g2_decap_4
XFILLER_35_186 VPWR VGND sg13g2_decap_8
X_1719_ _0465_ VPWR _0307_ VGND net150 _0074_ sg13g2_o21ai_1
XFILLER_25_76 VPWR VGND sg13g2_decap_8
XFILLER_26_131 VPWR VGND sg13g2_decap_8
XFILLER_41_112 VPWR VGND sg13g2_decap_8
XFILLER_42_602 VPWR VGND sg13g2_decap_8
XFILLER_41_189 VPWR VGND sg13g2_decap_8
XFILLER_41_42 VPWR VGND sg13g2_decap_8
XFILLER_6_536 VPWR VGND sg13g2_decap_8
XFILLER_1_252 VPWR VGND sg13g2_decap_8
XFILLER_2_25 VPWR VGND sg13g2_decap_8
XFILLER_2_753 VPWR VGND sg13g2_decap_8
XFILLER_17_153 VPWR VGND sg13g2_decap_8
XFILLER_18_643 VPWR VGND sg13g2_fill_2
XFILLER_18_665 VPWR VGND sg13g2_fill_1
XFILLER_33_613 VPWR VGND sg13g2_fill_1
XFILLER_37_429 VPWR VGND sg13g2_decap_4
XFILLER_45_462 VPWR VGND sg13g2_decap_8
XFILLER_49_256 VPWR VGND sg13g2_decap_8
XFILLER_18_698 VPWR VGND sg13g2_decap_8
XFILLER_20_307 VPWR VGND sg13g2_decap_4
XFILLER_32_123 VPWR VGND sg13g2_decap_8
X_0952_ VPWR _0067_ state\[45\] VGND sg13g2_inv_1
XFILLER_9_374 VPWR VGND sg13g2_decap_8
X_1504_ net167 VPWR _0572_ VGND net123 state\[87\] sg13g2_o21ai_1
X_1435_ _0197_ _0519_ _0520_ net44 _0770_ VPWR VGND sg13g2_a22oi_1
X_1366_ VGND VPWR net80 daisychain\[51\] _0469_ net41 sg13g2_a21oi_1
XFILLER_12_808 VPWR VGND sg13g2_decap_8
XFILLER_23_145 VPWR VGND sg13g2_decap_8
X_1297_ _0736_ net119 _0416_ _0417_ VPWR VGND sg13g2_a21o_1
XFILLER_11_34 VPWR VGND sg13g2_decap_8
XFILLER_36_53 VPWR VGND sg13g2_decap_8
XFILLER_46_259 VPWR VGND sg13g2_decap_8
XFILLER_47_749 VPWR VGND sg13g2_decap_8
XFILLER_14_145 VPWR VGND sg13g2_decap_8
XFILLER_30_616 VPWR VGND sg13g2_decap_8
XFILLER_11_874 VPWR VGND sg13g2_decap_8
XFILLER_6_333 VPWR VGND sg13g2_decap_8
XFILLER_2_550 VPWR VGND sg13g2_decap_8
XFILLER_38_716 VPWR VGND sg13g2_fill_1
X_1220_ net176 VPWR _0873_ VGND net132 state\[16\] sg13g2_o21ai_1
X_1151_ VPWR _0820_ daisychain\[119\] VGND sg13g2_inv_1
XFILLER_33_410 VPWR VGND sg13g2_decap_4
XFILLER_37_259 VPWR VGND sg13g2_decap_8
X_1082_ VPWR _0751_ daisychain\[50\] VGND sg13g2_inv_1
XFILLER_20_104 VPWR VGND sg13g2_decap_8
XFILLER_9_193 VPWR VGND sg13g2_decap_8
X_1984_ net193 VGND VPWR _0316_ state\[60\] clknet_leaf_0_clk sg13g2_dfrbpq_1
X_0935_ VPWR _0048_ state\[28\] VGND sg13g2_inv_1
XFILLER_28_248 VPWR VGND sg13g2_decap_4
XFILLER_44_708 VPWR VGND sg13g2_decap_8
X_1418_ VGND VPWR net79 daisychain\[64\] _0508_ net37 sg13g2_a21oi_1
X_1349_ _0749_ net107 _0455_ _0456_ VPWR VGND sg13g2_a21o_1
XFILLER_12_649 VPWR VGND sg13g2_decap_8
XFILLER_36_270 VPWR VGND sg13g2_decap_8
XFILLER_22_11 VPWR VGND sg13g2_decap_8
XFILLER_22_88 VPWR VGND sg13g2_decap_8
XFILLER_4_837 VPWR VGND sg13g2_decap_8
XFILLER_7_119 VPWR VGND sg13g2_decap_8
XFILLER_19_204 VPWR VGND sg13g2_decap_8
XFILLER_3_347 VPWR VGND sg13g2_decap_8
Xfanout150 net151 net150 VPWR VGND sg13g2_buf_1
Xfanout161 net162 net161 VPWR VGND sg13g2_buf_1
Xfanout172 net173 net172 VPWR VGND sg13g2_buf_1
Xfanout183 net188 net183 VPWR VGND sg13g2_buf_1
XFILLER_15_443 VPWR VGND sg13g2_decap_8
XFILLER_15_454 VPWR VGND sg13g2_fill_1
XFILLER_34_207 VPWR VGND sg13g2_decap_8
XFILLER_43_763 VPWR VGND sg13g2_decap_8
XFILLER_47_546 VPWR VGND sg13g2_decap_8
XFILLER_47_63 VPWR VGND sg13g2_decap_8
Xfanout194 net203 net194 VPWR VGND sg13g2_buf_1
XFILLER_15_498 VPWR VGND sg13g2_decap_4
XFILLER_42_273 VPWR VGND sg13g2_decap_8
XFILLER_7_620 VPWR VGND sg13g2_decap_8
XFILLER_8_46 VPWR VGND sg13g2_decap_8
XFILLER_6_130 VPWR VGND sg13g2_decap_8
XFILLER_33_4 VPWR VGND sg13g2_decap_8
XFILLER_38_546 VPWR VGND sg13g2_fill_2
X_1203_ _0139_ _0859_ _0860_ net65 _0712_ VPWR VGND sg13g2_a22oi_1
X_1134_ VPWR _0803_ daisychain\[102\] VGND sg13g2_inv_1
XFILLER_34_796 VPWR VGND sg13g2_fill_2
X_1065_ VPWR _0734_ daisychain\[33\] VGND sg13g2_inv_1
X_1967_ net204 VGND VPWR _0299_ state\[43\] clknet_leaf_12_clk sg13g2_dfrbpq_1
X_1898_ net214 VGND VPWR _0230_ daisychain\[102\] clknet_leaf_6_clk sg13g2_dfrbpq_1
X_0918_ VPWR _0022_ state\[11\] VGND sg13g2_inv_1
XFILLER_17_719 VPWR VGND sg13g2_fill_2
XFILLER_33_32 VPWR VGND sg13g2_decap_8
XFILLER_40_711 VPWR VGND sg13g2_fill_1
XFILLER_8_417 VPWR VGND sg13g2_decap_8
XFILLER_3_144 VPWR VGND sg13g2_decap_8
XFILLER_4_634 VPWR VGND sg13g2_decap_8
XFILLER_0_851 VPWR VGND sg13g2_decap_8
XFILLER_47_343 VPWR VGND sg13g2_decap_8
XFILLER_48_855 VPWR VGND sg13g2_decap_8
XFILLER_43_560 VPWR VGND sg13g2_decap_8
XFILLER_43_571 VPWR VGND sg13g2_fill_2
XFILLER_31_788 VPWR VGND sg13g2_fill_1
XFILLER_7_483 VPWR VGND sg13g2_decap_8
Xclkbuf_leaf_10_clk clknet_2_2__leaf_clk clknet_leaf_10_clk VPWR VGND sg13g2_buf_8
X_1821_ net207 VGND VPWR _0153_ daisychain\[25\] clknet_leaf_12_clk sg13g2_dfrbpq_1
X_1752_ _0564_ VPWR _0340_ VGND net157 _0110_ sg13g2_o21ai_1
X_1683_ _0871_ VPWR _0271_ VGND net176 _0034_ sg13g2_o21ai_1
XFILLER_39_888 VPWR VGND sg13g2_decap_8
X_1117_ VPWR _0786_ daisychain\[85\] VGND sg13g2_inv_1
XFILLER_0_91 VPWR VGND sg13g2_decap_8
XFILLER_10_917 VPWR VGND sg13g2_decap_8
X_1048_ VPWR _0717_ daisychain\[16\] VGND sg13g2_inv_1
XFILLER_0_147 VPWR VGND sg13g2_decap_8
XFILLER_1_648 VPWR VGND sg13g2_decap_8
XFILLER_28_32 VPWR VGND sg13g2_decap_8
XFILLER_13_722 VPWR VGND sg13g2_decap_4
XFILLER_28_98 VPWR VGND sg13g2_decap_8
XFILLER_44_357 VPWR VGND sg13g2_decap_8
XFILLER_44_42 VPWR VGND sg13g2_decap_8
XFILLER_45_847 VPWR VGND sg13g2_decap_8
XFILLER_12_276 VPWR VGND sg13g2_decap_8
XFILLER_13_766 VPWR VGND sg13g2_decap_8
XFILLER_13_788 VPWR VGND sg13g2_fill_2
XFILLER_5_921 VPWR VGND sg13g2_decap_4
XFILLER_8_214 VPWR VGND sg13g2_decap_8
XFILLER_9_759 VPWR VGND sg13g2_fill_2
XFILLER_9_737 VPWR VGND sg13g2_fill_2
XFILLER_9_726 VPWR VGND sg13g2_decap_8
XFILLER_4_431 VPWR VGND sg13g2_decap_8
XFILLER_5_25 VPWR VGND sg13g2_decap_8
XFILLER_47_140 VPWR VGND sg13g2_decap_8
XFILLER_48_630 VPWR VGND sg13g2_decap_8
X_2020_ net216 VGND VPWR _0352_ state\[96\] clknet_leaf_8_clk sg13g2_dfrbpq_1
XFILLER_16_560 VPWR VGND sg13g2_fill_1
XFILLER_7_280 VPWR VGND sg13g2_decap_8
X_1804_ net221 VGND VPWR _0136_ daisychain\[8\] clknet_leaf_10_clk sg13g2_dfrbpq_1
X_1735_ _0513_ VPWR _0323_ VGND net153 _0091_ sg13g2_o21ai_1
X_1666_ VGND VPWR net78 daisychain\[126\] _0694_ net35 sg13g2_a21oi_1
X_1597_ _0811_ net140 _0641_ _0642_ VPWR VGND sg13g2_a21o_1
XFILLER_38_140 VPWR VGND sg13g2_decap_8
XFILLER_39_696 VPWR VGND sg13g2_fill_2
XFILLER_42_806 VPWR VGND sg13g2_decap_8
XFILLER_10_758 VPWR VGND sg13g2_decap_8
XFILLER_14_45 VPWR VGND sg13g2_fill_2
XFILLER_5_228 VPWR VGND sg13g2_decap_8
XFILLER_1_445 VPWR VGND sg13g2_decap_8
XFILLER_30_99 VPWR VGND sg13g2_decap_8
XFILLER_39_42 VPWR VGND sg13g2_decap_8
XFILLER_18_803 VPWR VGND sg13g2_fill_1
XFILLER_29_195 VPWR VGND sg13g2_decap_8
XFILLER_45_644 VPWR VGND sg13g2_decap_8
XFILLER_13_530 VPWR VGND sg13g2_fill_1
XFILLER_13_574 VPWR VGND sg13g2_fill_1
XFILLER_41_850 VPWR VGND sg13g2_decap_8
XFILLER_44_154 VPWR VGND sg13g2_decap_8
X_1520_ net172 VPWR _0584_ VGND net127 state\[91\] sg13g2_o21ai_1
XFILLER_5_795 VPWR VGND sg13g2_decap_8
X_1451_ _0201_ _0531_ _0532_ net44 _0774_ VPWR VGND sg13g2_a22oi_1
X_1382_ VGND VPWR net81 daisychain\[55\] _0481_ net38 sg13g2_a21oi_1
XFILLER_17_880 VPWR VGND sg13g2_decap_8
XFILLER_35_165 VPWR VGND sg13g2_decap_8
XFILLER_36_644 VPWR VGND sg13g2_decap_8
XFILLER_36_699 VPWR VGND sg13g2_decap_4
X_2003_ net202 VGND VPWR _0335_ state\[79\] clknet_leaf_3_clk sg13g2_dfrbpq_1
X_1718_ _0462_ VPWR _0306_ VGND net150 _0073_ sg13g2_o21ai_1
X_1649_ net101 _0695_ _0680_ _0681_ VPWR VGND sg13g2_a21o_1
XFILLER_26_110 VPWR VGND sg13g2_decap_8
XFILLER_14_327 VPWR VGND sg13g2_decap_8
XFILLER_14_338 VPWR VGND sg13g2_fill_2
XFILLER_25_55 VPWR VGND sg13g2_decap_8
XFILLER_26_187 VPWR VGND sg13g2_decap_8
XFILLER_41_168 VPWR VGND sg13g2_decap_8
XFILLER_10_555 VPWR VGND sg13g2_fill_2
XFILLER_41_21 VPWR VGND sg13g2_decap_8
XFILLER_41_98 VPWR VGND sg13g2_decap_8
XFILLER_6_515 VPWR VGND sg13g2_decap_8
XFILLER_1_231 VPWR VGND sg13g2_decap_8
XFILLER_2_732 VPWR VGND sg13g2_decap_8
XFILLER_38_909 VPWR VGND sg13g2_decap_8
XFILLER_49_235 VPWR VGND sg13g2_decap_8
XFILLER_17_132 VPWR VGND sg13g2_decap_8
XFILLER_18_677 VPWR VGND sg13g2_decap_8
XFILLER_32_102 VPWR VGND sg13g2_decap_8
XFILLER_45_441 VPWR VGND sg13g2_decap_8
XFILLER_13_371 VPWR VGND sg13g2_decap_8
XFILLER_32_179 VPWR VGND sg13g2_decap_8
X_0951_ VPWR _0066_ state\[44\] VGND sg13g2_inv_1
XFILLER_5_592 VPWR VGND sg13g2_decap_8
XFILLER_9_397 VPWR VGND sg13g2_fill_1
X_1503_ _0214_ _0570_ _0571_ net56 _0787_ VPWR VGND sg13g2_a22oi_1
X_1434_ VGND VPWR net83 daisychain\[68\] _0520_ net43 sg13g2_a21oi_1
X_1365_ _0753_ net107 _0467_ _0468_ VPWR VGND sg13g2_a21o_1
X_1296_ net164 VPWR _0416_ VGND net119 state\[35\] sg13g2_o21ai_1
XFILLER_23_124 VPWR VGND sg13g2_decap_8
XFILLER_11_13 VPWR VGND sg13g2_decap_8
XFILLER_20_842 VPWR VGND sg13g2_decap_8
XFILLER_11_79 VPWR VGND sg13g2_decap_8
XFILLER_3_529 VPWR VGND sg13g2_decap_8
XFILLER_36_32 VPWR VGND sg13g2_decap_8
XFILLER_46_238 VPWR VGND sg13g2_decap_8
XFILLER_47_728 VPWR VGND sg13g2_decap_8
XFILLER_10_330 VPWR VGND sg13g2_decap_4
XFILLER_14_124 VPWR VGND sg13g2_decap_8
XFILLER_15_669 VPWR VGND sg13g2_fill_1
XFILLER_30_628 VPWR VGND sg13g2_decap_4
XFILLER_30_639 VPWR VGND sg13g2_decap_4
XFILLER_42_455 VPWR VGND sg13g2_decap_8
XFILLER_42_488 VPWR VGND sg13g2_decap_8
XFILLER_7_802 VPWR VGND sg13g2_decap_4
XFILLER_6_312 VPWR VGND sg13g2_decap_8
XFILLER_6_389 VPWR VGND sg13g2_decap_8
XFILLER_37_238 VPWR VGND sg13g2_decap_8
X_1150_ VPWR _0819_ daisychain\[118\] VGND sg13g2_inv_1
XFILLER_33_433 VPWR VGND sg13g2_decap_8
X_1081_ VPWR _0750_ daisychain\[49\] VGND sg13g2_inv_1
XFILLER_33_499 VPWR VGND sg13g2_fill_2
XFILLER_9_172 VPWR VGND sg13g2_decap_8
X_1983_ net193 VGND VPWR _0315_ state\[59\] clknet_leaf_0_clk sg13g2_dfrbpq_1
X_0934_ VPWR _0047_ state\[27\] VGND sg13g2_inv_1
X_1417_ _0766_ net103 _0506_ _0507_ VPWR VGND sg13g2_a21o_1
XFILLER_37_783 VPWR VGND sg13g2_decap_8
X_1348_ net151 VPWR _0455_ VGND net107 state\[48\] sg13g2_o21ai_1
X_1279_ _0158_ _0402_ _0403_ net55 _0731_ VPWR VGND sg13g2_a22oi_1
XFILLER_11_149 VPWR VGND sg13g2_decap_8
XFILLER_20_683 VPWR VGND sg13g2_decap_8
XFILLER_22_67 VPWR VGND sg13g2_decap_8
XFILLER_3_326 VPWR VGND sg13g2_decap_8
XFILLER_4_816 VPWR VGND sg13g2_decap_8
XFILLER_47_42 VPWR VGND sg13g2_decap_8
XFILLER_47_525 VPWR VGND sg13g2_decap_8
Xfanout140 net141 net140 VPWR VGND sg13g2_buf_1
Xfanout151 net152 net151 VPWR VGND sg13g2_buf_1
Xfanout162 net166 net162 VPWR VGND sg13g2_buf_1
Xfanout173 net189 net173 VPWR VGND sg13g2_buf_1
Xfanout184 net188 net184 VPWR VGND sg13g2_buf_1
Xfanout195 net197 net195 VPWR VGND sg13g2_buf_1
XFILLER_15_422 VPWR VGND sg13g2_decap_8
XFILLER_19_249 VPWR VGND sg13g2_fill_1
XFILLER_31_926 VPWR VGND sg13g2_fill_1
XFILLER_35_709 VPWR VGND sg13g2_fill_2
XFILLER_42_252 VPWR VGND sg13g2_decap_8
XFILLER_43_742 VPWR VGND sg13g2_decap_8
XFILLER_11_683 VPWR VGND sg13g2_fill_1
XFILLER_8_25 VPWR VGND sg13g2_decap_8
XFILLER_3_893 VPWR VGND sg13g2_decap_8
XFILLER_6_186 VPWR VGND sg13g2_decap_8
XFILLER_26_4 VPWR VGND sg13g2_decap_4
X_1202_ VGND VPWR net92 daisychain\[10\] _0860_ net65 sg13g2_a21oi_1
X_1133_ VPWR _0802_ daisychain\[101\] VGND sg13g2_inv_1
X_1064_ VPWR _0733_ daisychain\[32\] VGND sg13g2_inv_1
X_1966_ net204 VGND VPWR _0298_ state\[42\] clknet_leaf_12_clk sg13g2_dfrbpq_1
X_1897_ net214 VGND VPWR _0229_ daisychain\[101\] clknet_leaf_5_clk sg13g2_dfrbpq_1
X_0917_ VPWR _0011_ state\[10\] VGND sg13g2_inv_1
XFILLER_0_329 VPWR VGND sg13g2_decap_8
XFILLER_12_403 VPWR VGND sg13g2_fill_1
XFILLER_13_926 VPWR VGND sg13g2_fill_1
XFILLER_44_539 VPWR VGND sg13g2_decap_8
XFILLER_12_458 VPWR VGND sg13g2_fill_1
XFILLER_33_11 VPWR VGND sg13g2_decap_8
XFILLER_33_88 VPWR VGND sg13g2_decap_8
XFILLER_40_723 VPWR VGND sg13g2_decap_8
XFILLER_40_734 VPWR VGND sg13g2_fill_1
XFILLER_0_830 VPWR VGND sg13g2_decap_8
XFILLER_3_123 VPWR VGND sg13g2_decap_8
XFILLER_4_613 VPWR VGND sg13g2_decap_8
XFILLER_47_322 VPWR VGND sg13g2_decap_8
XFILLER_48_834 VPWR VGND sg13g2_decap_8
XFILLER_15_285 VPWR VGND sg13g2_decap_8
XFILLER_30_211 VPWR VGND sg13g2_fill_2
XFILLER_30_233 VPWR VGND sg13g2_fill_1
XFILLER_47_399 VPWR VGND sg13g2_decap_8
X_1820_ net207 VGND VPWR _0152_ daisychain\[24\] clknet_leaf_12_clk sg13g2_dfrbpq_1
XFILLER_30_266 VPWR VGND sg13g2_fill_2
XFILLER_7_462 VPWR VGND sg13g2_decap_8
X_1751_ _0561_ VPWR _0339_ VGND net169 _0109_ sg13g2_o21ai_1
X_1682_ _0868_ VPWR _0270_ VGND net180 _0033_ sg13g2_o21ai_1
XFILLER_39_823 VPWR VGND sg13g2_fill_1
XFILLER_3_690 VPWR VGND sg13g2_decap_8
XFILLER_0_70 VPWR VGND sg13g2_decap_8
XFILLER_17_0 VPWR VGND sg13g2_fill_1
XFILLER_39_867 VPWR VGND sg13g2_decap_8
X_1116_ VPWR _0785_ daisychain\[84\] VGND sg13g2_inv_1
X_1047_ VPWR _0716_ daisychain\[15\] VGND sg13g2_inv_1
X_1949_ net208 VGND VPWR _0281_ state\[25\] clknet_leaf_11_clk sg13g2_dfrbpq_1
XFILLER_0_126 VPWR VGND sg13g2_decap_8
XFILLER_1_627 VPWR VGND sg13g2_decap_8
XFILLER_28_11 VPWR VGND sg13g2_decap_8
XFILLER_45_826 VPWR VGND sg13g2_decap_8
XFILLER_48_119 VPWR VGND sg13g2_decap_8
XFILLER_44_21 VPWR VGND sg13g2_decap_8
XFILLER_44_336 VPWR VGND sg13g2_decap_8
XFILLER_44_98 VPWR VGND sg13g2_decap_8
XFILLER_9_716 VPWR VGND sg13g2_fill_2
XFILLER_12_255 VPWR VGND sg13g2_decap_8
XFILLER_40_575 VPWR VGND sg13g2_decap_8
XFILLER_4_410 VPWR VGND sg13g2_decap_8
XFILLER_5_900 VPWR VGND sg13g2_decap_8
XFILLER_39_119 VPWR VGND sg13g2_decap_8
XFILLER_4_487 VPWR VGND sg13g2_decap_8
XFILLER_36_815 VPWR VGND sg13g2_fill_2
XFILLER_47_196 VPWR VGND sg13g2_decap_8
XFILLER_48_686 VPWR VGND sg13g2_decap_8
X_1803_ net221 VGND VPWR _0135_ daisychain\[7\] clknet_leaf_10_clk sg13g2_dfrbpq_1
X_1734_ _0510_ VPWR _0322_ VGND net147 _0090_ sg13g2_o21ai_1
X_1665_ _0700_ net101 _0692_ _0693_ VPWR VGND sg13g2_a21o_1
X_1596_ net183 VPWR _0641_ VGND net140 state\[110\] sg13g2_o21ai_1
XFILLER_38_196 VPWR VGND sg13g2_decap_8
XFILLER_5_207 VPWR VGND sg13g2_decap_8
XFILLER_1_424 VPWR VGND sg13g2_decap_8
XFILLER_2_914 VPWR VGND sg13g2_decap_8
XFILLER_2_925 VPWR VGND sg13g2_fill_2
XFILLER_30_78 VPWR VGND sg13g2_decap_8
XFILLER_39_21 VPWR VGND sg13g2_decap_8
XFILLER_17_336 VPWR VGND sg13g2_decap_4
XFILLER_18_848 VPWR VGND sg13g2_decap_8
XFILLER_29_174 VPWR VGND sg13g2_decap_8
XFILLER_39_98 VPWR VGND sg13g2_decap_8
XFILLER_44_133 VPWR VGND sg13g2_decap_8
XFILLER_45_623 VPWR VGND sg13g2_decap_8
XFILLER_40_350 VPWR VGND sg13g2_fill_2
XFILLER_9_535 VPWR VGND sg13g2_fill_2
XFILLER_4_284 VPWR VGND sg13g2_decap_8
XFILLER_5_774 VPWR VGND sg13g2_decap_8
X_1450_ VGND VPWR net83 daisychain\[72\] _0532_ net44 sg13g2_a21oi_1
XFILLER_9_579 VPWR VGND sg13g2_fill_2
XFILLER_0_490 VPWR VGND sg13g2_decap_8
X_1381_ _0757_ net108 _0479_ _0480_ VPWR VGND sg13g2_a21o_1
XFILLER_35_144 VPWR VGND sg13g2_decap_8
XFILLER_36_678 VPWR VGND sg13g2_decap_8
XFILLER_48_483 VPWR VGND sg13g2_decap_8
X_2002_ net202 VGND VPWR _0334_ state\[78\] clknet_leaf_3_clk sg13g2_dfrbpq_1
X_1717_ _0459_ VPWR _0305_ VGND net152 _0071_ sg13g2_o21ai_1
X_1648_ net146 VPWR _0680_ VGND net100 state\[123\] sg13g2_o21ai_1
X_1579_ _0233_ _0627_ _0628_ net72 _0806_ VPWR VGND sg13g2_a22oi_1
XFILLER_10_501 VPWR VGND sg13g2_fill_2
XFILLER_10_523 VPWR VGND sg13g2_decap_8
XFILLER_10_534 VPWR VGND sg13g2_fill_2
XFILLER_14_306 VPWR VGND sg13g2_decap_8
XFILLER_25_34 VPWR VGND sg13g2_decap_8
XFILLER_26_166 VPWR VGND sg13g2_decap_8
XFILLER_41_147 VPWR VGND sg13g2_decap_8
XFILLER_1_210 VPWR VGND sg13g2_decap_8
XFILLER_2_711 VPWR VGND sg13g2_decap_8
XFILLER_41_77 VPWR VGND sg13g2_decap_8
XFILLER_1_287 VPWR VGND sg13g2_decap_8
XFILLER_2_788 VPWR VGND sg13g2_decap_8
XFILLER_46_910 VPWR VGND sg13g2_decap_8
XFILLER_49_214 VPWR VGND sg13g2_decap_8
XFILLER_17_111 VPWR VGND sg13g2_decap_8
XFILLER_17_188 VPWR VGND sg13g2_decap_8
XFILLER_18_656 VPWR VGND sg13g2_decap_8
XFILLER_33_648 VPWR VGND sg13g2_decap_4
XFILLER_45_420 VPWR VGND sg13g2_decap_8
XFILLER_45_497 VPWR VGND sg13g2_decap_8
XFILLER_32_158 VPWR VGND sg13g2_decap_8
XFILLER_9_354 VPWR VGND sg13g2_decap_4
X_0950_ VPWR _0065_ state\[43\] VGND sg13g2_inv_1
XFILLER_5_571 VPWR VGND sg13g2_decap_8
X_1502_ VGND VPWR net90 daisychain\[85\] _0571_ net56 sg13g2_a21oi_1
X_1433_ _0770_ net109 _0518_ _0519_ VPWR VGND sg13g2_a21o_1
XFILLER_48_280 VPWR VGND sg13g2_decap_8
XFILLER_49_781 VPWR VGND sg13g2_decap_8
X_1364_ net151 VPWR _0467_ VGND net106 state\[52\] sg13g2_o21ai_1
X_1295_ _0162_ _0414_ _0415_ net54 _0735_ VPWR VGND sg13g2_a22oi_1
XFILLER_23_103 VPWR VGND sg13g2_decap_8
XFILLER_20_887 VPWR VGND sg13g2_decap_8
XFILLER_3_508 VPWR VGND sg13g2_decap_8
XFILLER_47_707 VPWR VGND sg13g2_decap_8
XFILLER_14_103 VPWR VGND sg13g2_decap_8
XFILLER_36_11 VPWR VGND sg13g2_decap_8
XFILLER_36_88 VPWR VGND sg13g2_decap_8
XFILLER_39_280 VPWR VGND sg13g2_decap_8
XFILLER_42_434 VPWR VGND sg13g2_decap_8
XFILLER_43_924 VPWR VGND sg13g2_fill_2
XFILLER_46_217 VPWR VGND sg13g2_decap_8
XFILLER_30_607 VPWR VGND sg13g2_decap_4
XFILLER_6_368 VPWR VGND sg13g2_decap_8
XFILLER_19_921 VPWR VGND sg13g2_decap_4
XFILLER_2_585 VPWR VGND sg13g2_decap_8
XFILLER_37_217 VPWR VGND sg13g2_decap_8
X_1080_ VPWR _0749_ daisychain\[48\] VGND sg13g2_inv_1
XFILLER_18_486 VPWR VGND sg13g2_decap_4
XFILLER_20_139 VPWR VGND sg13g2_decap_8
XFILLER_34_924 VPWR VGND sg13g2_fill_2
XFILLER_45_294 VPWR VGND sg13g2_decap_8
XFILLER_46_784 VPWR VGND sg13g2_decap_8
X_1982_ net194 VGND VPWR _0314_ state\[58\] clknet_leaf_14_clk sg13g2_dfrbpq_1
XFILLER_13_191 VPWR VGND sg13g2_decap_8
XFILLER_6_880 VPWR VGND sg13g2_fill_2
XFILLER_9_151 VPWR VGND sg13g2_decap_8
X_0933_ VPWR _0046_ state\[26\] VGND sg13g2_inv_1
XFILLER_3_81 VPWR VGND sg13g2_decap_8
XFILLER_47_0 VPWR VGND sg13g2_decap_8
X_1416_ net147 VPWR _0506_ VGND net103 state\[65\] sg13g2_o21ai_1
X_1347_ _0175_ _0453_ _0454_ net51 _0748_ VPWR VGND sg13g2_a22oi_1
XFILLER_37_751 VPWR VGND sg13g2_fill_2
X_1278_ VGND VPWR net86 daisychain\[29\] _0403_ net55 sg13g2_a21oi_1
XFILLER_11_128 VPWR VGND sg13g2_decap_8
XFILLER_22_46 VPWR VGND sg13g2_decap_8
XFILLER_3_305 VPWR VGND sg13g2_decap_8
XFILLER_47_21 VPWR VGND sg13g2_decap_8
XFILLER_47_504 VPWR VGND sg13g2_decap_8
XFILLER_47_98 VPWR VGND sg13g2_decap_8
Xfanout130 net132 net130 VPWR VGND sg13g2_buf_1
Xfanout141 net145 net141 VPWR VGND sg13g2_buf_1
Xfanout152 net158 net152 VPWR VGND sg13g2_buf_1
Xfanout163 net164 net163 VPWR VGND sg13g2_buf_1
Xfanout174 net175 net174 VPWR VGND sg13g2_buf_1
Xfanout185 net188 net185 VPWR VGND sg13g2_buf_1
Xfanout196 net197 net196 VPWR VGND sg13g2_buf_1
XFILLER_16_913 VPWR VGND sg13g2_decap_8
XFILLER_27_250 VPWR VGND sg13g2_decap_8
XFILLER_42_231 VPWR VGND sg13g2_decap_8
XFILLER_43_721 VPWR VGND sg13g2_decap_8
XFILLER_43_798 VPWR VGND sg13g2_decap_8
XFILLER_10_183 VPWR VGND sg13g2_decap_8
XFILLER_12_90 VPWR VGND sg13g2_fill_1
XFILLER_6_165 VPWR VGND sg13g2_decap_8
XFILLER_7_677 VPWR VGND sg13g2_fill_1
XFILLER_2_382 VPWR VGND sg13g2_decap_8
XFILLER_3_872 VPWR VGND sg13g2_decap_8
XFILLER_40_7 VPWR VGND sg13g2_decap_8
X_1201_ _0712_ net131 _0858_ _0859_ VPWR VGND sg13g2_a21o_1
XFILLER_19_4 VPWR VGND sg13g2_fill_2
XFILLER_19_784 VPWR VGND sg13g2_decap_4
XFILLER_25_209 VPWR VGND sg13g2_decap_8
XFILLER_38_548 VPWR VGND sg13g2_fill_1
XFILLER_46_581 VPWR VGND sg13g2_decap_8
X_1132_ VPWR _0801_ daisychain\[100\] VGND sg13g2_inv_1
X_1063_ VPWR _0732_ daisychain\[31\] VGND sg13g2_inv_1
XFILLER_34_798 VPWR VGND sg13g2_fill_1
Xdigitalen3.g\[1\].u.inv1 VPWR digitalen3.g\[1\].u.OUTN net9 VGND sg13g2_inv_1
X_1965_ net204 VGND VPWR _0297_ state\[41\] clknet_leaf_13_clk sg13g2_dfrbpq_1
X_0916_ VPWR _0127_ state\[9\] VGND sg13g2_inv_1
XFILLER_0_308 VPWR VGND sg13g2_decap_8
XFILLER_1_809 VPWR VGND sg13g2_decap_8
X_1896_ net214 VGND VPWR _0228_ daisychain\[100\] clknet_leaf_5_clk sg13g2_dfrbpq_1
XFILLER_17_13 VPWR VGND sg13g2_fill_2
XFILLER_17_24 VPWR VGND sg13g2_decap_8
XFILLER_40_702 VPWR VGND sg13g2_decap_8
XFILLER_44_518 VPWR VGND sg13g2_decap_8
XFILLER_33_67 VPWR VGND sg13g2_decap_8
XFILLER_3_102 VPWR VGND sg13g2_decap_8
XFILLER_40_757 VPWR VGND sg13g2_fill_2
XFILLER_3_179 VPWR VGND sg13g2_decap_8
XFILLER_4_669 VPWR VGND sg13g2_decap_8
XFILLER_0_897 VPWR VGND sg13g2_decap_8
XFILLER_16_721 VPWR VGND sg13g2_fill_2
XFILLER_47_301 VPWR VGND sg13g2_decap_8
XFILLER_47_378 VPWR VGND sg13g2_decap_8
XFILLER_48_813 VPWR VGND sg13g2_decap_8
XFILLER_15_264 VPWR VGND sg13g2_decap_8
XFILLER_16_754 VPWR VGND sg13g2_fill_1
XFILLER_43_595 VPWR VGND sg13g2_decap_8
X_1750_ _0558_ VPWR _0338_ VGND net170 _0108_ sg13g2_o21ai_1
XFILLER_11_481 VPWR VGND sg13g2_fill_2
XFILLER_7_441 VPWR VGND sg13g2_decap_8
X_1681_ _0865_ VPWR _0269_ VGND net180 _0032_ sg13g2_o21ai_1
XFILLER_38_301 VPWR VGND sg13g2_decap_8
X_1115_ VPWR _0784_ daisychain\[83\] VGND sg13g2_inv_1
X_1046_ VPWR _0715_ daisychain\[14\] VGND sg13g2_inv_1
XFILLER_21_223 VPWR VGND sg13g2_fill_2
X_1948_ net208 VGND VPWR _0280_ state\[24\] clknet_leaf_12_clk sg13g2_dfrbpq_1
X_1879_ net201 VGND VPWR _0211_ daisychain\[83\] clknet_leaf_2_clk sg13g2_dfrbpq_1
XFILLER_0_105 VPWR VGND sg13g2_decap_8
XFILLER_1_606 VPWR VGND sg13g2_decap_8
XFILLER_44_315 VPWR VGND sg13g2_decap_8
XFILLER_45_805 VPWR VGND sg13g2_decap_8
XFILLER_12_234 VPWR VGND sg13g2_decap_8
XFILLER_44_77 VPWR VGND sg13g2_decap_8
XFILLER_4_466 VPWR VGND sg13g2_decap_8
XFILLER_8_249 VPWR VGND sg13g2_decap_8
XFILLER_0_694 VPWR VGND sg13g2_decap_8
XFILLER_10_8 VPWR VGND sg13g2_decap_8
XFILLER_36_827 VPWR VGND sg13g2_decap_4
XFILLER_47_175 VPWR VGND sg13g2_decap_8
XFILLER_48_665 VPWR VGND sg13g2_decap_8
Xclkbuf_2_3__f_clk clknet_2_3__leaf_clk clknet_0_clk VPWR VGND sg13g2_buf_16
XFILLER_31_521 VPWR VGND sg13g2_decap_8
XFILLER_31_532 VPWR VGND sg13g2_fill_2
XFILLER_31_598 VPWR VGND sg13g2_fill_1
XFILLER_43_392 VPWR VGND sg13g2_decap_8
X_1802_ net220 VGND VPWR _0134_ daisychain\[6\] clknet_leaf_10_clk sg13g2_dfrbpq_1
X_1733_ _0507_ VPWR _0321_ VGND net147 _0089_ sg13g2_o21ai_1
X_1664_ net146 VPWR _0692_ VGND net101 state\[127\] sg13g2_o21ai_1
X_1595_ _0237_ _0639_ _0640_ net71 _0810_ VPWR VGND sg13g2_a22oi_1
XFILLER_38_175 VPWR VGND sg13g2_decap_8
XFILLER_39_698 VPWR VGND sg13g2_fill_1
XFILLER_14_47 VPWR VGND sg13g2_fill_1
XFILLER_35_882 VPWR VGND sg13g2_decap_4
XFILLER_41_329 VPWR VGND sg13g2_decap_8
X_1029_ VPWR _0025_ state\[122\] VGND sg13g2_inv_1
XFILLER_30_57 VPWR VGND sg13g2_decap_8
XFILLER_6_709 VPWR VGND sg13g2_decap_8
XFILLER_39_77 VPWR VGND sg13g2_decap_8
XFILLER_49_429 VPWR VGND sg13g2_decap_8
XFILLER_29_153 VPWR VGND sg13g2_decap_8
XFILLER_44_112 VPWR VGND sg13g2_decap_8
XFILLER_44_189 VPWR VGND sg13g2_decap_8
XFILLER_45_602 VPWR VGND sg13g2_decap_8
XFILLER_45_679 VPWR VGND sg13g2_decap_8
XFILLER_13_565 VPWR VGND sg13g2_decap_8
XFILLER_13_598 VPWR VGND sg13g2_decap_8
XFILLER_41_885 VPWR VGND sg13g2_decap_8
XFILLER_20_90 VPWR VGND sg13g2_decap_8
XFILLER_4_263 VPWR VGND sg13g2_decap_8
XFILLER_5_753 VPWR VGND sg13g2_decap_8
X_1380_ net151 VPWR _0479_ VGND net108 state\[56\] sg13g2_o21ai_1
XFILLER_48_462 VPWR VGND sg13g2_decap_8
X_2001_ net200 VGND VPWR _0333_ state\[77\] clknet_leaf_2_clk sg13g2_dfrbpq_1
XFILLER_16_370 VPWR VGND sg13g2_decap_8
XFILLER_35_123 VPWR VGND sg13g2_decap_8
X_1716_ _0456_ VPWR _0304_ VGND net151 _0070_ sg13g2_o21ai_1
XFILLER_6_81 VPWR VGND sg13g2_decap_8
X_1647_ _0250_ _0678_ _0679_ net34 _0823_ VPWR VGND sg13g2_a22oi_1
X_1578_ VGND VPWR net96 daisychain\[104\] _0628_ net72 sg13g2_a21oi_1
XFILLER_25_13 VPWR VGND sg13g2_decap_8
XFILLER_26_145 VPWR VGND sg13g2_decap_8
XFILLER_42_616 VPWR VGND sg13g2_decap_8
XFILLER_42_627 VPWR VGND sg13g2_fill_1
XFILLER_41_126 VPWR VGND sg13g2_decap_8
XFILLER_41_56 VPWR VGND sg13g2_decap_8
XFILLER_2_767 VPWR VGND sg13g2_decap_8
XFILLER_1_266 VPWR VGND sg13g2_decap_8
XFILLER_2_39 VPWR VGND sg13g2_decap_8
XFILLER_17_167 VPWR VGND sg13g2_decap_8
XFILLER_32_137 VPWR VGND sg13g2_decap_8
XFILLER_45_476 VPWR VGND sg13g2_decap_8
XFILLER_14_896 VPWR VGND sg13g2_decap_4
XFILLER_5_550 VPWR VGND sg13g2_decap_8
XFILLER_9_333 VPWR VGND sg13g2_decap_8
XFILLER_49_4 VPWR VGND sg13g2_decap_8
X_1501_ _0787_ net124 _0569_ _0570_ VPWR VGND sg13g2_a21o_1
X_1432_ net153 VPWR _0518_ VGND net109 state\[69\] sg13g2_o21ai_1
X_1363_ _0179_ _0465_ _0466_ net41 _0752_ VPWR VGND sg13g2_a22oi_1
XFILLER_37_922 VPWR VGND sg13g2_decap_4
X_1294_ VGND VPWR net85 daisychain\[33\] _0415_ net52 sg13g2_a21oi_1
XFILLER_20_877 VPWR VGND sg13g2_fill_1
XFILLER_23_159 VPWR VGND sg13g2_decap_8
XFILLER_11_48 VPWR VGND sg13g2_decap_8
XFILLER_20_899 VPWR VGND sg13g2_decap_8
XFILLER_14_159 VPWR VGND sg13g2_decap_8
XFILLER_15_616 VPWR VGND sg13g2_fill_2
XFILLER_36_67 VPWR VGND sg13g2_decap_8
XFILLER_42_413 VPWR VGND sg13g2_decap_8
XFILLER_43_903 VPWR VGND sg13g2_decap_8
XFILLER_11_822 VPWR VGND sg13g2_fill_2
XFILLER_11_888 VPWR VGND sg13g2_decap_8
XFILLER_6_347 VPWR VGND sg13g2_decap_8
XFILLER_2_564 VPWR VGND sg13g2_decap_8
XFILLER_7_0 VPWR VGND sg13g2_decap_8
XFILLER_34_903 VPWR VGND sg13g2_decap_8
XFILLER_46_763 VPWR VGND sg13g2_decap_8
XFILLER_13_170 VPWR VGND sg13g2_decap_8
XFILLER_20_118 VPWR VGND sg13g2_decap_8
XFILLER_45_273 VPWR VGND sg13g2_decap_8
XFILLER_9_130 VPWR VGND sg13g2_decap_8
X_1981_ net194 VGND VPWR _0313_ state\[57\] clknet_leaf_14_clk sg13g2_dfrbpq_1
X_0932_ VPWR _0045_ state\[25\] VGND sg13g2_inv_1
XFILLER_28_207 VPWR VGND sg13g2_fill_1
XFILLER_3_60 VPWR VGND sg13g2_decap_8
X_1415_ _0192_ _0504_ _0505_ net43 _0765_ VPWR VGND sg13g2_a22oi_1
X_1346_ VGND VPWR net84 daisychain\[46\] _0454_ net42 sg13g2_a21oi_1
XFILLER_36_284 VPWR VGND sg13g2_decap_8
XFILLER_37_730 VPWR VGND sg13g2_decap_8
XFILLER_40_906 VPWR VGND sg13g2_decap_8
X_1277_ _0731_ net120 _0401_ _0402_ VPWR VGND sg13g2_a21o_1
XFILLER_11_107 VPWR VGND sg13g2_decap_8
XFILLER_20_663 VPWR VGND sg13g2_fill_1
XFILLER_22_25 VPWR VGND sg13g2_decap_8
XFILLER_32_490 VPWR VGND sg13g2_fill_1
XFILLER_0_7 VPWR VGND sg13g2_decap_8
Xfanout120 net121 net120 VPWR VGND sg13g2_buf_1
Xfanout131 net132 net131 VPWR VGND sg13g2_buf_1
XFILLER_19_218 VPWR VGND sg13g2_decap_8
XFILLER_19_229 VPWR VGND sg13g2_fill_1
XFILLER_43_700 VPWR VGND sg13g2_decap_8
XFILLER_47_77 VPWR VGND sg13g2_decap_8
Xfanout142 net144 net142 VPWR VGND sg13g2_buf_1
Xfanout153 net154 net153 VPWR VGND sg13g2_buf_1
Xfanout164 net166 net164 VPWR VGND sg13g2_buf_1
Xfanout175 net176 net175 VPWR VGND sg13g2_buf_1
Xfanout186 net187 net186 VPWR VGND sg13g2_buf_1
Xfanout197 net203 net197 VPWR VGND sg13g2_buf_1
XFILLER_42_210 VPWR VGND sg13g2_decap_8
XFILLER_42_287 VPWR VGND sg13g2_decap_8
XFILLER_43_777 VPWR VGND sg13g2_decap_8
XFILLER_10_162 VPWR VGND sg13g2_decap_8
XFILLER_6_144 VPWR VGND sg13g2_decap_8
XFILLER_7_634 VPWR VGND sg13g2_fill_2
XFILLER_2_361 VPWR VGND sg13g2_decap_8
XFILLER_3_851 VPWR VGND sg13g2_decap_8
X_1200_ net177 VPWR _0858_ VGND net131 state\[11\] sg13g2_o21ai_1
XFILLER_19_763 VPWR VGND sg13g2_decap_8
XFILLER_33_221 VPWR VGND sg13g2_decap_8
XFILLER_46_560 VPWR VGND sg13g2_decap_8
X_1131_ VPWR _0800_ daisychain\[99\] VGND sg13g2_inv_1
X_1062_ VPWR _0731_ daisychain\[30\] VGND sg13g2_inv_1
Xclkbuf_leaf_13_clk clknet_2_0__leaf_clk clknet_leaf_13_clk VPWR VGND sg13g2_buf_8
Xdigitalen3.g\[1\].u.inv2 VPWR digitalen3.g\[1\].u.OUTP digitalen3.g\[1\].u.OUTN VGND
+ sg13g2_inv_1
X_1964_ net206 VGND VPWR _0296_ state\[40\] clknet_leaf_14_clk sg13g2_dfrbpq_1
X_1895_ net214 VGND VPWR _0227_ daisychain\[99\] clknet_leaf_5_clk sg13g2_dfrbpq_1
X_0915_ VPWR _0116_ state\[8\] VGND sg13g2_inv_1
X_1329_ _0744_ net115 _0440_ _0441_ VPWR VGND sg13g2_a21o_1
XFILLER_12_449 VPWR VGND sg13g2_decap_8
XFILLER_17_69 VPWR VGND sg13g2_decap_8
XFILLER_33_46 VPWR VGND sg13g2_decap_8
XFILLER_37_571 VPWR VGND sg13g2_decap_8
XFILLER_40_769 VPWR VGND sg13g2_decap_8
XFILLER_4_648 VPWR VGND sg13g2_decap_8
XFILLER_0_876 VPWR VGND sg13g2_decap_8
XFILLER_3_158 VPWR VGND sg13g2_decap_8
XFILLER_15_243 VPWR VGND sg13g2_decap_8
XFILLER_47_357 VPWR VGND sg13g2_decap_8
XFILLER_48_869 VPWR VGND sg13g2_decap_8
XFILLER_30_268 VPWR VGND sg13g2_fill_1
XFILLER_7_420 VPWR VGND sg13g2_decap_8
XFILLER_7_497 VPWR VGND sg13g2_decap_4
X_1680_ _0862_ VPWR _0268_ VGND net179 _0031_ sg13g2_o21ai_1
XFILLER_31_4 VPWR VGND sg13g2_decap_8
XFILLER_38_357 VPWR VGND sg13g2_decap_4
XFILLER_38_379 VPWR VGND sg13g2_decap_8
Xclkbuf_leaf_2_clk clknet_2_1__leaf_clk clknet_leaf_2_clk VPWR VGND sg13g2_buf_8
X_1114_ VPWR _0783_ daisychain\[82\] VGND sg13g2_inv_1
XFILLER_34_552 VPWR VGND sg13g2_decap_8
X_1045_ VPWR _0714_ daisychain\[13\] VGND sg13g2_inv_1
X_1947_ net208 VGND VPWR _0279_ state\[23\] clknet_leaf_11_clk sg13g2_dfrbpq_1
X_1878_ net211 VGND VPWR _0210_ daisychain\[82\] clknet_leaf_4_clk sg13g2_dfrbpq_1
XFILLER_9_81 VPWR VGND sg13g2_decap_8
XFILLER_28_46 VPWR VGND sg13g2_decap_8
XFILLER_28_57 VPWR VGND sg13g2_fill_2
XFILLER_12_213 VPWR VGND sg13g2_decap_8
XFILLER_40_522 VPWR VGND sg13g2_decap_8
XFILLER_40_533 VPWR VGND sg13g2_fill_2
XFILLER_40_599 VPWR VGND sg13g2_decap_8
XFILLER_44_56 VPWR VGND sg13g2_decap_8
XFILLER_8_228 VPWR VGND sg13g2_decap_8
XFILLER_9_718 VPWR VGND sg13g2_fill_1
XFILLER_4_445 VPWR VGND sg13g2_decap_8
XFILLER_5_39 VPWR VGND sg13g2_decap_8
XFILLER_0_673 VPWR VGND sg13g2_decap_8
XFILLER_35_305 VPWR VGND sg13g2_decap_8
XFILLER_47_154 VPWR VGND sg13g2_decap_8
XFILLER_48_644 VPWR VGND sg13g2_decap_8
XFILLER_18_90 VPWR VGND sg13g2_decap_8
XFILLER_36_839 VPWR VGND sg13g2_decap_8
XFILLER_43_371 VPWR VGND sg13g2_decap_8
XFILLER_44_883 VPWR VGND sg13g2_decap_8
XFILLER_31_566 VPWR VGND sg13g2_fill_1
XFILLER_8_773 VPWR VGND sg13g2_decap_8
X_1801_ net220 VGND VPWR _0133_ daisychain\[5\] clknet_leaf_10_clk sg13g2_dfrbpq_1
X_1732_ _0504_ VPWR _0320_ VGND net153 _0088_ sg13g2_o21ai_1
X_1663_ _0254_ _0690_ _0691_ net35 _0699_ VPWR VGND sg13g2_a22oi_1
XFILLER_7_294 VPWR VGND sg13g2_decap_8
X_1594_ VGND VPWR net96 daisychain\[108\] _0640_ net73 sg13g2_a21oi_1
XFILLER_38_154 VPWR VGND sg13g2_decap_8
XFILLER_39_622 VPWR VGND sg13g2_decap_4
XFILLER_39_655 VPWR VGND sg13g2_decap_8
XFILLER_14_26 VPWR VGND sg13g2_fill_2
XFILLER_41_308 VPWR VGND sg13g2_decap_8
X_1028_ VPWR _0024_ state\[121\] VGND sg13g2_inv_1
XFILLER_30_25 VPWR VGND sg13g2_decap_8
Xdigitalen1.g\[0\].u.inv1 VPWR digitalen1.g\[0\].u.OUTN net7 VGND sg13g2_inv_1
XFILLER_1_459 VPWR VGND sg13g2_decap_8
XFILLER_29_132 VPWR VGND sg13g2_decap_8
XFILLER_39_56 VPWR VGND sg13g2_decap_8
XFILLER_49_408 VPWR VGND sg13g2_decap_8
XFILLER_44_168 VPWR VGND sg13g2_decap_8
XFILLER_45_658 VPWR VGND sg13g2_decap_8
XFILLER_40_352 VPWR VGND sg13g2_fill_1
XFILLER_41_864 VPWR VGND sg13g2_decap_8
XFILLER_5_732 VPWR VGND sg13g2_decap_8
XFILLER_4_242 VPWR VGND sg13g2_decap_8
XFILLER_35_102 VPWR VGND sg13g2_decap_8
XFILLER_48_441 VPWR VGND sg13g2_decap_8
X_2000_ net200 VGND VPWR _0332_ state\[76\] clknet_leaf_2_clk sg13g2_dfrbpq_1
XFILLER_32_820 VPWR VGND sg13g2_decap_4
XFILLER_32_886 VPWR VGND sg13g2_fill_1
XFILLER_35_179 VPWR VGND sg13g2_decap_8
XFILLER_6_60 VPWR VGND sg13g2_decap_8
X_1715_ _0453_ VPWR _0303_ VGND net161 _0069_ sg13g2_o21ai_1
X_1646_ VGND VPWR net78 daisychain\[121\] _0679_ net34 sg13g2_a21oi_1
X_1577_ _0806_ net139 _0626_ _0627_ VPWR VGND sg13g2_a21o_1
XFILLER_25_69 VPWR VGND sg13g2_decap_8
XFILLER_26_124 VPWR VGND sg13g2_decap_8
XFILLER_41_105 VPWR VGND sg13g2_decap_8
XFILLER_42_639 VPWR VGND sg13g2_fill_2
XFILLER_10_503 VPWR VGND sg13g2_fill_1
XFILLER_10_569 VPWR VGND sg13g2_decap_4
XFILLER_41_35 VPWR VGND sg13g2_decap_8
XFILLER_6_529 VPWR VGND sg13g2_decap_8
XFILLER_1_245 VPWR VGND sg13g2_decap_8
XFILLER_2_746 VPWR VGND sg13g2_decap_8
XFILLER_9_4 VPWR VGND sg13g2_decap_8
XFILLER_17_146 VPWR VGND sg13g2_decap_8
XFILLER_18_636 VPWR VGND sg13g2_decap_8
XFILLER_2_18 VPWR VGND sg13g2_decap_8
XFILLER_45_455 VPWR VGND sg13g2_decap_8
XFILLER_49_249 VPWR VGND sg13g2_decap_8
XFILLER_14_820 VPWR VGND sg13g2_fill_2
XFILLER_32_116 VPWR VGND sg13g2_decap_8
XFILLER_41_672 VPWR VGND sg13g2_fill_1
XFILLER_41_683 VPWR VGND sg13g2_decap_4
XFILLER_9_312 VPWR VGND sg13g2_decap_8
XFILLER_40_182 VPWR VGND sg13g2_decap_8
XFILLER_9_367 VPWR VGND sg13g2_decap_8
X_1500_ net167 VPWR _0569_ VGND net123 state\[86\] sg13g2_o21ai_1
XFILLER_37_901 VPWR VGND sg13g2_decap_8
XFILLER_49_750 VPWR VGND sg13g2_fill_1
X_1431_ _0196_ _0516_ _0517_ net43 _0769_ VPWR VGND sg13g2_a22oi_1
X_1362_ VGND VPWR net80 daisychain\[50\] _0466_ net41 sg13g2_a21oi_1
X_1293_ _0735_ net119 _0413_ _0414_ VPWR VGND sg13g2_a21o_1
XFILLER_23_138 VPWR VGND sg13g2_decap_8
XFILLER_36_466 VPWR VGND sg13g2_fill_2
XFILLER_36_499 VPWR VGND sg13g2_decap_8
XFILLER_20_834 VPWR VGND sg13g2_decap_4
XFILLER_31_193 VPWR VGND sg13g2_decap_8
XFILLER_11_27 VPWR VGND sg13g2_decap_8
X_1629_ _0819_ net143 _0665_ _0666_ VPWR VGND sg13g2_a21o_1
XFILLER_36_46 VPWR VGND sg13g2_decap_8
XFILLER_11_834 VPWR VGND sg13g2_fill_1
XFILLER_14_138 VPWR VGND sg13g2_decap_8
XFILLER_43_926 VPWR VGND sg13g2_fill_1
XFILLER_22_193 VPWR VGND sg13g2_decap_4
XFILLER_6_326 VPWR VGND sg13g2_decap_8
XFILLER_2_543 VPWR VGND sg13g2_decap_8
XFILLER_33_414 VPWR VGND sg13g2_fill_1
XFILLER_34_926 VPWR VGND sg13g2_fill_1
XFILLER_45_252 VPWR VGND sg13g2_decap_8
XFILLER_46_742 VPWR VGND sg13g2_decap_8
X_1980_ net196 VGND VPWR _0312_ state\[56\] clknet_leaf_14_clk sg13g2_dfrbpq_1
X_0931_ VPWR _0044_ state\[24\] VGND sg13g2_inv_1
XFILLER_6_860 VPWR VGND sg13g2_fill_1
XFILLER_9_186 VPWR VGND sg13g2_decap_8
X_1414_ VGND VPWR net83 daisychain\[63\] _0505_ net43 sg13g2_a21oi_1
X_1345_ _0748_ net122 _0452_ _0453_ VPWR VGND sg13g2_a21o_1
X_1276_ net165 VPWR _0401_ VGND net120 state\[30\] sg13g2_o21ai_1
XFILLER_36_263 VPWR VGND sg13g2_decap_8
XFILLER_20_697 VPWR VGND sg13g2_fill_1
Xfanout110 net114 net110 VPWR VGND sg13g2_buf_1
Xfanout121 net122 net121 VPWR VGND sg13g2_buf_1
Xfanout132 net138 net132 VPWR VGND sg13g2_buf_1
Xfanout143 net144 net143 VPWR VGND sg13g2_buf_1
Xfanout154 net157 net154 VPWR VGND sg13g2_buf_1
Xfanout165 net166 net165 VPWR VGND sg13g2_buf_1
XFILLER_15_436 VPWR VGND sg13g2_decap_8
XFILLER_47_539 VPWR VGND sg13g2_decap_8
XFILLER_47_56 VPWR VGND sg13g2_decap_8
Xfanout176 net181 net176 VPWR VGND sg13g2_buf_1
Xfanout187 net188 net187 VPWR VGND sg13g2_buf_1
Xfanout198 net199 net198 VPWR VGND sg13g2_buf_1
XFILLER_10_141 VPWR VGND sg13g2_decap_8
XFILLER_42_266 VPWR VGND sg13g2_decap_8
XFILLER_43_756 VPWR VGND sg13g2_decap_8
XFILLER_7_613 VPWR VGND sg13g2_decap_8
XFILLER_8_39 VPWR VGND sg13g2_decap_8
XFILLER_11_697 VPWR VGND sg13g2_fill_2
XFILLER_2_340 VPWR VGND sg13g2_decap_8
XFILLER_3_830 VPWR VGND sg13g2_decap_8
XFILLER_6_123 VPWR VGND sg13g2_decap_8
XFILLER_38_539 VPWR VGND sg13g2_fill_2
X_1130_ VPWR _0799_ daisychain\[98\] VGND sg13g2_inv_1
XFILLER_18_296 VPWR VGND sg13g2_decap_4
XFILLER_33_200 VPWR VGND sg13g2_decap_8
XFILLER_33_288 VPWR VGND sg13g2_fill_2
XFILLER_34_789 VPWR VGND sg13g2_decap_8
X_1061_ VPWR _0730_ daisychain\[29\] VGND sg13g2_inv_1
X_1963_ net206 VGND VPWR _0295_ state\[39\] clknet_leaf_13_clk sg13g2_dfrbpq_1
X_1894_ net215 VGND VPWR _0226_ daisychain\[98\] clknet_leaf_5_clk sg13g2_dfrbpq_1
X_0914_ VPWR _0105_ state\[7\] VGND sg13g2_inv_1
X_1328_ net160 VPWR _0440_ VGND net115 state\[43\] sg13g2_o21ai_1
X_1259_ _0153_ _0387_ _0388_ net53 _0726_ VPWR VGND sg13g2_a22oi_1
XFILLER_20_450 VPWR VGND sg13g2_fill_2
XFILLER_24_277 VPWR VGND sg13g2_decap_4
XFILLER_33_25 VPWR VGND sg13g2_decap_8
XFILLER_3_137 VPWR VGND sg13g2_decap_8
XFILLER_4_627 VPWR VGND sg13g2_decap_8
XFILLER_0_800 VPWR VGND sg13g2_decap_8
XFILLER_0_844 VPWR VGND sg13g2_decap_8
XFILLER_47_336 VPWR VGND sg13g2_decap_8
XFILLER_48_848 VPWR VGND sg13g2_decap_8
XFILLER_15_222 VPWR VGND sg13g2_decap_8
XFILLER_43_553 VPWR VGND sg13g2_decap_8
XFILLER_15_299 VPWR VGND sg13g2_decap_8
XFILLER_7_476 VPWR VGND sg13g2_decap_8
XFILLER_8_911 VPWR VGND sg13g2_decap_8
XFILLER_19_561 VPWR VGND sg13g2_fill_2
XFILLER_24_4 VPWR VGND sg13g2_decap_4
X_1113_ VPWR _0782_ daisychain\[81\] VGND sg13g2_inv_1
X_1044_ VPWR _0713_ daisychain\[12\] VGND sg13g2_inv_1
XFILLER_0_84 VPWR VGND sg13g2_decap_8
XFILLER_21_214 VPWR VGND sg13g2_decap_4
XFILLER_21_225 VPWR VGND sg13g2_fill_1
XFILLER_9_60 VPWR VGND sg13g2_decap_8
X_1946_ net217 VGND VPWR _0278_ state\[22\] clknet_leaf_11_clk sg13g2_dfrbpq_1
X_1877_ net213 VGND VPWR _0209_ daisychain\[81\] clknet_leaf_3_clk sg13g2_dfrbpq_1
XFILLER_28_25 VPWR VGND sg13g2_decap_8
XFILLER_13_726 VPWR VGND sg13g2_fill_1
XFILLER_38_881 VPWR VGND sg13g2_decap_8
XFILLER_44_35 VPWR VGND sg13g2_decap_8
XFILLER_12_269 VPWR VGND sg13g2_decap_8
XFILLER_13_759 VPWR VGND sg13g2_decap_8
XFILLER_5_914 VPWR VGND sg13g2_decap_8
XFILLER_8_207 VPWR VGND sg13g2_decap_8
XFILLER_4_424 VPWR VGND sg13g2_decap_8
XFILLER_5_18 VPWR VGND sg13g2_decap_8
XFILLER_5_925 VPWR VGND sg13g2_fill_2
XFILLER_0_652 VPWR VGND sg13g2_decap_8
XFILLER_47_133 VPWR VGND sg13g2_decap_8
XFILLER_48_623 VPWR VGND sg13g2_decap_8
XFILLER_16_531 VPWR VGND sg13g2_decap_8
XFILLER_16_553 VPWR VGND sg13g2_decap_8
XFILLER_35_339 VPWR VGND sg13g2_decap_4
XFILLER_43_350 VPWR VGND sg13g2_decap_8
XFILLER_44_862 VPWR VGND sg13g2_decap_8
X_1800_ net220 VGND VPWR _0132_ daisychain\[4\] clknet_leaf_10_clk sg13g2_dfrbpq_1
XFILLER_7_273 VPWR VGND sg13g2_decap_8
XFILLER_8_796 VPWR VGND sg13g2_fill_2
X_1731_ _0501_ VPWR _0319_ VGND net148 _0087_ sg13g2_o21ai_1
X_1662_ VGND VPWR net78 daisychain\[125\] _0691_ net35 sg13g2_a21oi_1
XFILLER_39_645 VPWR VGND sg13g2_decap_8
X_1593_ _0810_ net140 _0638_ _0639_ VPWR VGND sg13g2_a21o_1
XFILLER_38_133 VPWR VGND sg13g2_decap_8
XFILLER_39_689 VPWR VGND sg13g2_decap_8
X_1027_ VPWR _0023_ state\[120\] VGND sg13g2_inv_1
XFILLER_14_38 VPWR VGND sg13g2_decap_8
X_1929_ net220 VGND VPWR _0261_ state\[5\] clknet_leaf_10_clk sg13g2_dfrbpq_1
XFILLER_1_438 VPWR VGND sg13g2_decap_8
Xdigitalen1.g\[0\].u.inv2 VPWR digitalen1.g\[0\].u.OUTP digitalen1.g\[0\].u.OUTN VGND
+ sg13g2_inv_1
XFILLER_17_317 VPWR VGND sg13g2_fill_2
XFILLER_29_111 VPWR VGND sg13g2_decap_8
XFILLER_29_188 VPWR VGND sg13g2_decap_8
XFILLER_39_35 VPWR VGND sg13g2_decap_8
XFILLER_45_637 VPWR VGND sg13g2_decap_8
XFILLER_41_843 VPWR VGND sg13g2_decap_8
XFILLER_44_147 VPWR VGND sg13g2_decap_8
XFILLER_40_364 VPWR VGND sg13g2_decap_4
XFILLER_4_221 VPWR VGND sg13g2_decap_8
XFILLER_5_711 VPWR VGND sg13g2_decap_8
XFILLER_48_420 VPWR VGND sg13g2_decap_8
XFILLER_4_298 VPWR VGND sg13g2_decap_8
XFILLER_5_788 VPWR VGND sg13g2_decap_8
XFILLER_17_873 VPWR VGND sg13g2_decap_4
XFILLER_29_90 VPWR VGND sg13g2_decap_8
XFILLER_35_158 VPWR VGND sg13g2_decap_8
XFILLER_48_497 VPWR VGND sg13g2_decap_8
X_1714_ _0450_ VPWR _0302_ VGND net161 _0068_ sg13g2_o21ai_1
X_1645_ _0823_ net100 _0677_ _0678_ VPWR VGND sg13g2_a21o_1
X_1576_ net182 VPWR _0626_ VGND net139 state\[105\] sg13g2_o21ai_1
XFILLER_26_103 VPWR VGND sg13g2_decap_8
Xdigitalen2.g\[2\].u.inv1 VPWR digitalen2.g\[2\].u.OUTN net8 VGND sg13g2_inv_1
XFILLER_25_48 VPWR VGND sg13g2_decap_8
X_2059_ ena net17 VPWR VGND sg13g2_buf_1
XFILLER_10_548 VPWR VGND sg13g2_decap_8
XFILLER_41_14 VPWR VGND sg13g2_decap_8
XFILLER_6_508 VPWR VGND sg13g2_decap_8
XFILLER_1_224 VPWR VGND sg13g2_decap_8
XFILLER_2_725 VPWR VGND sg13g2_decap_8
XFILLER_49_228 VPWR VGND sg13g2_decap_8
XFILLER_17_125 VPWR VGND sg13g2_decap_8
XFILLER_45_434 VPWR VGND sg13g2_decap_8
XFILLER_46_924 VPWR VGND sg13g2_fill_2
XFILLER_13_364 VPWR VGND sg13g2_fill_2
XFILLER_40_161 VPWR VGND sg13g2_decap_8
XFILLER_5_585 VPWR VGND sg13g2_decap_8
X_1430_ VGND VPWR net83 daisychain\[67\] _0517_ net43 sg13g2_a21oi_1
XFILLER_49_795 VPWR VGND sg13g2_decap_8
X_1361_ _0752_ net107 _0464_ _0465_ VPWR VGND sg13g2_a21o_1
X_1292_ net164 VPWR _0413_ VGND net119 state\[34\] sg13g2_o21ai_1
XFILLER_23_117 VPWR VGND sg13g2_decap_8
XFILLER_48_294 VPWR VGND sg13g2_decap_8
XFILLER_31_172 VPWR VGND sg13g2_decap_8
XFILLER_9_891 VPWR VGND sg13g2_fill_2
X_1628_ net186 VPWR _0665_ VGND net143 state\[118\] sg13g2_o21ai_1
X_1559_ _0228_ _0612_ _0613_ net60 _0801_ VPWR VGND sg13g2_a22oi_1
XFILLER_36_25 VPWR VGND sg13g2_decap_8
XFILLER_39_294 VPWR VGND sg13g2_decap_8
XFILLER_10_323 VPWR VGND sg13g2_decap_8
XFILLER_11_824 VPWR VGND sg13g2_fill_1
XFILLER_14_117 VPWR VGND sg13g2_decap_8
XFILLER_22_172 VPWR VGND sg13g2_decap_8
XFILLER_42_448 VPWR VGND sg13g2_decap_8
XFILLER_2_522 VPWR VGND sg13g2_decap_8
XFILLER_6_305 VPWR VGND sg13g2_decap_8
XFILLER_2_599 VPWR VGND sg13g2_decap_8
XFILLER_18_412 VPWR VGND sg13g2_decap_4
XFILLER_33_426 VPWR VGND sg13g2_decap_8
XFILLER_45_231 VPWR VGND sg13g2_decap_8
XFILLER_46_721 VPWR VGND sg13g2_decap_8
XFILLER_46_798 VPWR VGND sg13g2_decap_8
XFILLER_9_165 VPWR VGND sg13g2_decap_8
X_0930_ VPWR _0043_ state\[23\] VGND sg13g2_inv_1
XFILLER_5_382 VPWR VGND sg13g2_decap_8
X_1413_ _0765_ net109 _0503_ _0504_ VPWR VGND sg13g2_a21o_1
XFILLER_36_242 VPWR VGND sg13g2_decap_8
XFILLER_37_721 VPWR VGND sg13g2_decap_4
XFILLER_37_765 VPWR VGND sg13g2_fill_1
XFILLER_37_776 VPWR VGND sg13g2_decap_8
XFILLER_3_95 VPWR VGND sg13g2_decap_8
X_1344_ net161 VPWR _0452_ VGND net122 state\[47\] sg13g2_o21ai_1
X_1275_ _0157_ _0399_ _0400_ net55 _0730_ VPWR VGND sg13g2_a22oi_1
XFILLER_20_643 VPWR VGND sg13g2_fill_2
XFILLER_32_481 VPWR VGND sg13g2_fill_2
XFILLER_20_676 VPWR VGND sg13g2_decap_8
XFILLER_3_319 VPWR VGND sg13g2_decap_8
XFILLER_4_809 VPWR VGND sg13g2_decap_8
XFILLER_47_35 VPWR VGND sg13g2_decap_8
XFILLER_47_518 VPWR VGND sg13g2_decap_8
Xfanout100 net101 net100 VPWR VGND sg13g2_buf_1
Xfanout111 net113 net111 VPWR VGND sg13g2_buf_1
Xfanout122 net129 net122 VPWR VGND sg13g2_buf_1
Xfanout133 net135 net133 VPWR VGND sg13g2_buf_1
Xfanout144 net145 net144 VPWR VGND sg13g2_buf_1
Xfanout155 net156 net155 VPWR VGND sg13g2_buf_1
Xfanout166 net189 net166 VPWR VGND sg13g2_buf_1
Xfanout177 net179 net177 VPWR VGND sg13g2_buf_1
Xfanout188 net189 net188 VPWR VGND sg13g2_buf_1
Xfanout199 net203 net199 VPWR VGND sg13g2_buf_1
XFILLER_31_919 VPWR VGND sg13g2_decap_8
XFILLER_42_245 VPWR VGND sg13g2_decap_8
XFILLER_43_735 VPWR VGND sg13g2_decap_8
XFILLER_10_120 VPWR VGND sg13g2_decap_8
XFILLER_6_102 VPWR VGND sg13g2_decap_8
XFILLER_8_18 VPWR VGND sg13g2_decap_8
XFILLER_10_197 VPWR VGND sg13g2_decap_8
XFILLER_3_886 VPWR VGND sg13g2_decap_8
XFILLER_6_179 VPWR VGND sg13g2_decap_8
XFILLER_19_743 VPWR VGND sg13g2_fill_1
XFILLER_19_776 VPWR VGND sg13g2_fill_2
XFILLER_26_8 VPWR VGND sg13g2_fill_1
XFILLER_2_396 VPWR VGND sg13g2_decap_8
X_1060_ VPWR _0729_ daisychain\[28\] VGND sg13g2_inv_1
XFILLER_46_595 VPWR VGND sg13g2_decap_8
X_1962_ net205 VGND VPWR _0294_ state\[38\] clknet_leaf_13_clk sg13g2_dfrbpq_1
X_1893_ net215 VGND VPWR _0225_ daisychain\[97\] clknet_leaf_4_clk sg13g2_dfrbpq_1
X_0913_ VPWR _0094_ state\[6\] VGND sg13g2_inv_1
XFILLER_45_0 VPWR VGND sg13g2_decap_8
XFILLER_37_595 VPWR VGND sg13g2_decap_8
X_1327_ _0170_ _0438_ _0439_ net49 _0743_ VPWR VGND sg13g2_a22oi_1
X_1258_ VGND VPWR net85 daisychain\[24\] _0388_ net53 sg13g2_a21oi_1
X_1189_ _0709_ net134 _0849_ _0850_ VPWR VGND sg13g2_a21o_1
XFILLER_3_116 VPWR VGND sg13g2_decap_8
XFILLER_4_606 VPWR VGND sg13g2_decap_8
XFILLER_47_315 VPWR VGND sg13g2_decap_8
XFILLER_48_827 VPWR VGND sg13g2_decap_8
XFILLER_15_201 VPWR VGND sg13g2_decap_8
XFILLER_15_278 VPWR VGND sg13g2_decap_8
XFILLER_16_702 VPWR VGND sg13g2_fill_1
XFILLER_30_204 VPWR VGND sg13g2_decap_8
XFILLER_43_532 VPWR VGND sg13g2_decap_8
XFILLER_7_455 VPWR VGND sg13g2_decap_8
XFILLER_2_193 VPWR VGND sg13g2_decap_8
XFILLER_3_683 VPWR VGND sg13g2_decap_8
XFILLER_0_63 VPWR VGND sg13g2_decap_8
XFILLER_38_315 VPWR VGND sg13g2_decap_8
XFILLER_46_392 VPWR VGND sg13g2_decap_8
XFILLER_47_882 VPWR VGND sg13g2_decap_8
X_1112_ VPWR _0781_ daisychain\[80\] VGND sg13g2_inv_1
X_1043_ VPWR _0712_ daisychain\[11\] VGND sg13g2_inv_1
XFILLER_21_204 VPWR VGND sg13g2_decap_4
XFILLER_30_760 VPWR VGND sg13g2_fill_1
XFILLER_30_793 VPWR VGND sg13g2_fill_2
X_1945_ net217 VGND VPWR _0277_ state\[21\] clknet_leaf_11_clk sg13g2_dfrbpq_1
X_1876_ net202 VGND VPWR _0208_ daisychain\[80\] clknet_leaf_3_clk sg13g2_dfrbpq_1
XFILLER_0_119 VPWR VGND sg13g2_decap_8
XFILLER_45_819 VPWR VGND sg13g2_decap_8
XFILLER_44_14 VPWR VGND sg13g2_decap_8
XFILLER_44_329 VPWR VGND sg13g2_decap_8
XFILLER_9_709 VPWR VGND sg13g2_decap_8
XFILLER_12_248 VPWR VGND sg13g2_decap_8
XFILLER_40_546 VPWR VGND sg13g2_fill_2
XFILLER_4_403 VPWR VGND sg13g2_decap_8
XFILLER_0_631 VPWR VGND sg13g2_decap_8
XFILLER_48_602 VPWR VGND sg13g2_decap_8
XFILLER_44_841 VPWR VGND sg13g2_decap_8
XFILLER_47_112 VPWR VGND sg13g2_decap_8
XFILLER_47_189 VPWR VGND sg13g2_decap_8
XFILLER_48_679 VPWR VGND sg13g2_decap_8
XFILLER_7_252 VPWR VGND sg13g2_decap_8
X_1730_ _0498_ VPWR _0318_ VGND net147 _0086_ sg13g2_o21ai_1
X_1661_ _0699_ net101 _0689_ _0690_ VPWR VGND sg13g2_a21o_1
X_1592_ net183 VPWR _0638_ VGND net140 state\[109\] sg13g2_o21ai_1
XFILLER_38_112 VPWR VGND sg13g2_decap_8
XFILLER_3_480 VPWR VGND sg13g2_decap_8
XFILLER_34_340 VPWR VGND sg13g2_fill_1
XFILLER_35_830 VPWR VGND sg13g2_decap_4
XFILLER_38_189 VPWR VGND sg13g2_decap_8
X_2075_ daisychain\[127\] net33 VPWR VGND sg13g2_buf_1
X_1026_ VPWR _0021_ state\[119\] VGND sg13g2_inv_1
X_1928_ net223 VGND VPWR _0260_ state\[4\] clknet_leaf_10_clk sg13g2_dfrbpq_1
X_1859_ net193 VGND VPWR _0191_ daisychain\[63\] clknet_leaf_1_clk sg13g2_dfrbpq_1
XFILLER_1_417 VPWR VGND sg13g2_decap_8
XFILLER_2_907 VPWR VGND sg13g2_decap_8
XFILLER_39_14 VPWR VGND sg13g2_decap_8
XFILLER_17_329 VPWR VGND sg13g2_fill_2
XFILLER_29_167 VPWR VGND sg13g2_decap_8
XFILLER_44_126 VPWR VGND sg13g2_decap_8
XFILLER_45_616 VPWR VGND sg13g2_decap_8
XFILLER_40_343 VPWR VGND sg13g2_decap_8
XFILLER_41_899 VPWR VGND sg13g2_decap_8
XFILLER_9_528 VPWR VGND sg13g2_decap_8
XFILLER_4_200 VPWR VGND sg13g2_decap_8
XFILLER_5_767 VPWR VGND sg13g2_decap_8
XFILLER_0_483 VPWR VGND sg13g2_decap_8
XFILLER_4_277 VPWR VGND sg13g2_decap_8
XFILLER_16_351 VPWR VGND sg13g2_fill_1
XFILLER_17_863 VPWR VGND sg13g2_decap_8
XFILLER_35_137 VPWR VGND sg13g2_decap_8
XFILLER_36_616 VPWR VGND sg13g2_decap_4
XFILLER_44_693 VPWR VGND sg13g2_decap_4
XFILLER_48_476 VPWR VGND sg13g2_decap_8
X_1713_ _0447_ VPWR _0301_ VGND net160 _0067_ sg13g2_o21ai_1
XFILLER_6_95 VPWR VGND sg13g2_decap_8
X_1644_ net146 VPWR _0677_ VGND net100 state\[122\] sg13g2_o21ai_1
X_1575_ _0232_ _0624_ _0625_ net72 _0805_ VPWR VGND sg13g2_a22oi_1
Xdigitalen2.g\[2\].u.inv2 VPWR digitalen2.g\[2\].u.OUTP digitalen2.g\[2\].u.OUTN VGND
+ sg13g2_inv_1
XFILLER_10_516 VPWR VGND sg13g2_decap_8
XFILLER_25_27 VPWR VGND sg13g2_decap_8
XFILLER_26_159 VPWR VGND sg13g2_decap_8
X_2058_ ena net16 VPWR VGND sg13g2_buf_1
X_1009_ VPWR _0003_ state\[102\] VGND sg13g2_inv_1
XFILLER_2_704 VPWR VGND sg13g2_decap_8
XFILLER_1_203 VPWR VGND sg13g2_decap_8
XFILLER_49_207 VPWR VGND sg13g2_decap_8
XFILLER_17_104 VPWR VGND sg13g2_decap_8
XFILLER_45_413 VPWR VGND sg13g2_decap_8
XFILLER_46_903 VPWR VGND sg13g2_decap_8
XFILLER_14_888 VPWR VGND sg13g2_fill_1
XFILLER_15_82 VPWR VGND sg13g2_decap_8
XFILLER_25_181 VPWR VGND sg13g2_decap_8
XFILLER_40_140 VPWR VGND sg13g2_decap_8
XFILLER_9_347 VPWR VGND sg13g2_decap_8
XFILLER_31_81 VPWR VGND sg13g2_decap_8
XFILLER_5_564 VPWR VGND sg13g2_decap_8
X_1360_ net151 VPWR _0464_ VGND net107 state\[51\] sg13g2_o21ai_1
XFILLER_0_280 VPWR VGND sg13g2_decap_8
XFILLER_1_781 VPWR VGND sg13g2_decap_8
XFILLER_48_273 VPWR VGND sg13g2_decap_8
XFILLER_49_774 VPWR VGND sg13g2_decap_8
X_1291_ _0161_ _0411_ _0412_ net52 _0734_ VPWR VGND sg13g2_a22oi_1
XFILLER_17_660 VPWR VGND sg13g2_decap_4
XFILLER_31_151 VPWR VGND sg13g2_decap_8
XFILLER_32_652 VPWR VGND sg13g2_fill_2
XFILLER_36_446 VPWR VGND sg13g2_decap_4
XFILLER_36_468 VPWR VGND sg13g2_fill_1
XFILLER_44_490 VPWR VGND sg13g2_decap_8
X_1627_ _0245_ _0663_ _0664_ net75 _0818_ VPWR VGND sg13g2_a22oi_1
X_1558_ VGND VPWR net88 daisychain\[99\] _0613_ net60 sg13g2_a21oi_1
X_1489_ _0784_ net124 _0560_ _0561_ VPWR VGND sg13g2_a21o_1
XFILLER_39_273 VPWR VGND sg13g2_decap_8
XFILLER_42_427 VPWR VGND sg13g2_decap_8
XFILLER_43_917 VPWR VGND sg13g2_decap_8
XFILLER_10_302 VPWR VGND sg13g2_decap_8
XFILLER_22_151 VPWR VGND sg13g2_decap_8
XFILLER_2_501 VPWR VGND sg13g2_decap_8
XFILLER_19_925 VPWR VGND sg13g2_fill_2
XFILLER_2_578 VPWR VGND sg13g2_decap_8
XFILLER_45_210 VPWR VGND sg13g2_decap_8
XFILLER_46_700 VPWR VGND sg13g2_decap_8
XFILLER_18_479 VPWR VGND sg13g2_decap_8
XFILLER_34_917 VPWR VGND sg13g2_decap_8
XFILLER_41_460 VPWR VGND sg13g2_fill_1
XFILLER_45_287 VPWR VGND sg13g2_decap_8
XFILLER_46_777 VPWR VGND sg13g2_decap_8
XFILLER_13_184 VPWR VGND sg13g2_decap_8
XFILLER_41_493 VPWR VGND sg13g2_fill_1
XFILLER_42_91 VPWR VGND sg13g2_decap_8
XFILLER_6_840 VPWR VGND sg13g2_fill_1
XFILLER_6_873 VPWR VGND sg13g2_decap_8
XFILLER_9_144 VPWR VGND sg13g2_decap_8
XFILLER_3_74 VPWR VGND sg13g2_decap_8
XFILLER_5_361 VPWR VGND sg13g2_decap_8
XFILLER_6_895 VPWR VGND sg13g2_decap_8
X_1412_ net153 VPWR _0503_ VGND net109 state\[64\] sg13g2_o21ai_1
X_1343_ _0174_ _0450_ _0451_ net42 _0747_ VPWR VGND sg13g2_a22oi_1
XFILLER_36_221 VPWR VGND sg13g2_decap_8
XFILLER_37_744 VPWR VGND sg13g2_decap_8
X_1274_ VGND VPWR net86 daisychain\[28\] _0400_ net54 sg13g2_a21oi_1
XFILLER_22_39 VPWR VGND sg13g2_decap_8
XFILLER_36_298 VPWR VGND sg13g2_decap_8
Xclkbuf_leaf_16_clk clknet_2_0__leaf_clk clknet_leaf_16_clk VPWR VGND sg13g2_buf_8
X_0989_ VPWR _0108_ state\[82\] VGND sg13g2_inv_1
XFILLER_47_14 VPWR VGND sg13g2_decap_8
Xfanout101 net102 net101 VPWR VGND sg13g2_buf_1
Xfanout112 net113 net112 VPWR VGND sg13g2_buf_1
Xfanout123 net124 net123 VPWR VGND sg13g2_buf_1
Xfanout134 net137 net134 VPWR VGND sg13g2_buf_1
Xfanout145 net5 net145 VPWR VGND sg13g2_buf_1
Xfanout156 net157 net156 VPWR VGND sg13g2_buf_1
Xfanout167 net169 net167 VPWR VGND sg13g2_buf_1
Xfanout178 net179 net178 VPWR VGND sg13g2_buf_1
Xfanout189 net4 net189 VPWR VGND sg13g2_buf_1
XFILLER_42_224 VPWR VGND sg13g2_decap_8
XFILLER_43_714 VPWR VGND sg13g2_decap_8
Xdigitalen0.g\[1\].u.inv1 VPWR digitalen0.g\[1\].u.OUTN net6 VGND sg13g2_inv_1
XFILLER_10_176 VPWR VGND sg13g2_decap_8
XFILLER_11_688 VPWR VGND sg13g2_fill_1
XFILLER_6_158 VPWR VGND sg13g2_decap_8
XFILLER_12_94 VPWR VGND sg13g2_decap_8
XFILLER_2_375 VPWR VGND sg13g2_decap_8
XFILLER_3_865 VPWR VGND sg13g2_decap_8
XFILLER_19_788 VPWR VGND sg13g2_fill_1
XFILLER_34_725 VPWR VGND sg13g2_fill_2
XFILLER_37_91 VPWR VGND sg13g2_decap_8
XFILLER_46_574 VPWR VGND sg13g2_decap_8
XFILLER_14_460 VPWR VGND sg13g2_fill_2
XFILLER_14_493 VPWR VGND sg13g2_decap_8
XFILLER_33_235 VPWR VGND sg13g2_fill_2
X_1961_ net205 VGND VPWR _0293_ state\[37\] clknet_leaf_12_clk sg13g2_dfrbpq_1
X_1892_ net216 VGND VPWR _0224_ daisychain\[96\] clknet_leaf_4_clk sg13g2_dfrbpq_1
X_0912_ VPWR _0083_ state\[5\] VGND sg13g2_inv_1
XFILLER_6_670 VPWR VGND sg13g2_decap_8
XFILLER_38_0 VPWR VGND sg13g2_decap_8
Xclkbuf_leaf_5_clk clknet_2_3__leaf_clk clknet_leaf_5_clk VPWR VGND sg13g2_buf_8
X_1326_ VGND VPWR net87 daisychain\[41\] _0439_ net49 sg13g2_a21oi_1
X_1257_ _0726_ net118 _0386_ _0387_ VPWR VGND sg13g2_a21o_1
X_1188_ net177 VPWR _0849_ VGND net134 state\[8\] sg13g2_o21ai_1
XFILLER_20_452 VPWR VGND sg13g2_fill_1
XFILLER_33_791 VPWR VGND sg13g2_fill_1
XFILLER_43_511 VPWR VGND sg13g2_decap_8
XFILLER_48_806 VPWR VGND sg13g2_decap_8
XFILLER_15_257 VPWR VGND sg13g2_decap_8
XFILLER_30_249 VPWR VGND sg13g2_fill_2
XFILLER_31_728 VPWR VGND sg13g2_fill_2
XFILLER_43_588 VPWR VGND sg13g2_decap_8
XFILLER_23_82 VPWR VGND sg13g2_decap_8
XFILLER_7_434 VPWR VGND sg13g2_decap_8
XFILLER_2_172 VPWR VGND sg13g2_decap_8
XFILLER_3_662 VPWR VGND sg13g2_decap_8
XFILLER_0_42 VPWR VGND sg13g2_decap_8
XFILLER_19_530 VPWR VGND sg13g2_decap_4
XFILLER_19_563 VPWR VGND sg13g2_fill_1
XFILLER_38_349 VPWR VGND sg13g2_fill_2
XFILLER_46_371 VPWR VGND sg13g2_decap_8
XFILLER_47_861 VPWR VGND sg13g2_decap_8
X_1111_ VPWR _0780_ daisychain\[79\] VGND sg13g2_inv_1
X_1042_ VPWR _0711_ daisychain\[10\] VGND sg13g2_inv_1
XFILLER_15_791 VPWR VGND sg13g2_decap_8
X_1944_ net217 VGND VPWR _0276_ state\[20\] clknet_leaf_11_clk sg13g2_dfrbpq_1
X_1875_ net202 VGND VPWR _0207_ daisychain\[79\] clknet_leaf_3_clk sg13g2_dfrbpq_1
XFILLER_9_95 VPWR VGND sg13g2_decap_8
XFILLER_44_308 VPWR VGND sg13g2_decap_8
X_1309_ _0739_ net116 _0425_ _0426_ VPWR VGND sg13g2_a21o_1
XFILLER_12_227 VPWR VGND sg13g2_decap_8
XFILLER_0_610 VPWR VGND sg13g2_decap_8
XFILLER_0_687 VPWR VGND sg13g2_decap_8
XFILLER_4_459 VPWR VGND sg13g2_decap_8
XFILLER_16_566 VPWR VGND sg13g2_decap_8
XFILLER_44_820 VPWR VGND sg13g2_decap_8
XFILLER_47_168 VPWR VGND sg13g2_decap_8
XFILLER_48_658 VPWR VGND sg13g2_decap_8
XFILLER_11_282 VPWR VGND sg13g2_decap_8
XFILLER_12_750 VPWR VGND sg13g2_decap_8
XFILLER_12_794 VPWR VGND sg13g2_fill_2
XFILLER_31_514 VPWR VGND sg13g2_decap_8
XFILLER_34_81 VPWR VGND sg13g2_decap_8
XFILLER_43_385 VPWR VGND sg13g2_decap_8
XFILLER_44_897 VPWR VGND sg13g2_decap_8
XFILLER_7_231 VPWR VGND sg13g2_decap_8
XFILLER_8_787 VPWR VGND sg13g2_decap_4
X_1660_ net146 VPWR _0689_ VGND net101 state\[126\] sg13g2_o21ai_1
X_1591_ _0236_ _0636_ _0637_ net71 _0809_ VPWR VGND sg13g2_a22oi_1
XFILLER_38_168 VPWR VGND sg13g2_decap_8
XFILLER_39_636 VPWR VGND sg13g2_decap_4
XFILLER_35_875 VPWR VGND sg13g2_decap_8
XFILLER_35_886 VPWR VGND sg13g2_fill_2
X_2074_ daisychain\[126\] net32 VPWR VGND sg13g2_buf_1
X_1025_ VPWR _0020_ state\[118\] VGND sg13g2_inv_1
XFILLER_30_39 VPWR VGND sg13g2_fill_1
X_1927_ net223 VGND VPWR _0259_ state\[3\] clknet_leaf_10_clk sg13g2_dfrbpq_1
X_1858_ net191 VGND VPWR _0190_ daisychain\[62\] clknet_leaf_0_clk sg13g2_dfrbpq_1
X_1789_ _0675_ VPWR _0377_ VGND net184 _0024_ sg13g2_o21ai_1
XFILLER_17_319 VPWR VGND sg13g2_fill_1
XFILLER_29_146 VPWR VGND sg13g2_decap_8
XFILLER_41_801 VPWR VGND sg13g2_decap_8
XFILLER_44_105 VPWR VGND sg13g2_decap_8
XFILLER_40_322 VPWR VGND sg13g2_decap_8
XFILLER_41_878 VPWR VGND sg13g2_decap_8
XFILLER_20_83 VPWR VGND sg13g2_decap_8
XFILLER_4_256 VPWR VGND sg13g2_decap_8
XFILLER_5_746 VPWR VGND sg13g2_decap_8
XFILLER_0_462 VPWR VGND sg13g2_decap_8
XFILLER_48_455 VPWR VGND sg13g2_decap_8
XFILLER_49_912 VPWR VGND sg13g2_decap_8
XFILLER_16_363 VPWR VGND sg13g2_fill_2
XFILLER_17_897 VPWR VGND sg13g2_fill_1
XFILLER_32_801 VPWR VGND sg13g2_fill_1
XFILLER_35_116 VPWR VGND sg13g2_decap_8
XFILLER_43_182 VPWR VGND sg13g2_decap_8
XFILLER_44_672 VPWR VGND sg13g2_decap_8
XFILLER_45_91 VPWR VGND sg13g2_decap_8
XANTENNA_1 VPWR VGND _0041_ sg13g2_antennanp
XFILLER_31_388 VPWR VGND sg13g2_decap_4
X_1712_ _0444_ VPWR _0300_ VGND net160 _0066_ sg13g2_o21ai_1
X_1643_ _0249_ _0675_ _0676_ net34 _0822_ VPWR VGND sg13g2_a22oi_1
XFILLER_6_74 VPWR VGND sg13g2_decap_8
X_1574_ VGND VPWR net96 daisychain\[103\] _0625_ net72 sg13g2_a21oi_1
XFILLER_19_190 VPWR VGND sg13g2_decap_8
XFILLER_26_138 VPWR VGND sg13g2_decap_8
XFILLER_42_609 VPWR VGND sg13g2_decap_8
X_2057_ ena net15 VPWR VGND sg13g2_buf_1
XFILLER_34_193 VPWR VGND sg13g2_decap_8
XFILLER_41_119 VPWR VGND sg13g2_decap_8
X_1008_ VPWR _0002_ state\[101\] VGND sg13g2_inv_1
XFILLER_41_49 VPWR VGND sg13g2_decap_8
XFILLER_1_259 VPWR VGND sg13g2_decap_8
XFILLER_46_926 VPWR VGND sg13g2_fill_1
XFILLER_25_160 VPWR VGND sg13g2_decap_8
XFILLER_45_469 VPWR VGND sg13g2_decap_8
XFILLER_31_60 VPWR VGND sg13g2_decap_8
XFILLER_40_196 VPWR VGND sg13g2_decap_8
XFILLER_41_664 VPWR VGND sg13g2_fill_1
XFILLER_9_326 VPWR VGND sg13g2_decap_8
XFILLER_1_760 VPWR VGND sg13g2_decap_8
XFILLER_5_543 VPWR VGND sg13g2_decap_8
XFILLER_37_915 VPWR VGND sg13g2_decap_8
XFILLER_37_926 VPWR VGND sg13g2_fill_1
XFILLER_48_252 VPWR VGND sg13g2_decap_8
X_1290_ VGND VPWR net86 daisychain\[32\] _0412_ net63 sg13g2_a21oi_1
XFILLER_16_182 VPWR VGND sg13g2_decap_8
XFILLER_17_683 VPWR VGND sg13g2_decap_4
XFILLER_31_130 VPWR VGND sg13g2_decap_8
XFILLER_32_686 VPWR VGND sg13g2_fill_1
X_1626_ VGND VPWR net97 daisychain\[116\] _0664_ net75 sg13g2_a21oi_1
XFILLER_9_893 VPWR VGND sg13g2_fill_1
XFILLER_9_882 VPWR VGND sg13g2_decap_4
XFILLER_39_252 VPWR VGND sg13g2_decap_8
X_1557_ _0801_ net127 _0611_ _0612_ VPWR VGND sg13g2_a21o_1
X_1488_ net169 VPWR _0560_ VGND net124 state\[83\] sg13g2_o21ai_1
XFILLER_42_406 VPWR VGND sg13g2_decap_8
XFILLER_22_130 VPWR VGND sg13g2_decap_8
XFILLER_2_557 VPWR VGND sg13g2_decap_8
XFILLER_46_756 VPWR VGND sg13g2_decap_8
XFILLER_13_163 VPWR VGND sg13g2_decap_8
XFILLER_14_631 VPWR VGND sg13g2_fill_1
XFILLER_14_653 VPWR VGND sg13g2_fill_1
XFILLER_26_82 VPWR VGND sg13g2_decap_8
XFILLER_45_266 VPWR VGND sg13g2_decap_8
XFILLER_9_123 VPWR VGND sg13g2_decap_8
XFILLER_42_70 VPWR VGND sg13g2_decap_8
XFILLER_5_340 VPWR VGND sg13g2_decap_8
XFILLER_3_53 VPWR VGND sg13g2_decap_8
X_1411_ _0191_ _0501_ _0502_ net38 _0764_ VPWR VGND sg13g2_a22oi_1
X_1342_ VGND VPWR net80 daisychain\[45\] _0451_ net40 sg13g2_a21oi_1
X_1273_ _0730_ net120 _0398_ _0399_ VPWR VGND sg13g2_a21o_1
XFILLER_36_200 VPWR VGND sg13g2_decap_8
XFILLER_36_277 VPWR VGND sg13g2_decap_8
XFILLER_20_612 VPWR VGND sg13g2_decap_4
XFILLER_22_18 VPWR VGND sg13g2_decap_8
XFILLER_32_494 VPWR VGND sg13g2_fill_1
X_0988_ VPWR _0107_ state\[81\] VGND sg13g2_inv_1
Xfanout102 net103 net102 VPWR VGND sg13g2_buf_1
Xfanout113 net114 net113 VPWR VGND sg13g2_buf_1
X_1609_ _0814_ net142 _0650_ _0651_ VPWR VGND sg13g2_a21o_1
Xfanout124 net125 net124 VPWR VGND sg13g2_buf_1
Xfanout135 net137 net135 VPWR VGND sg13g2_buf_1
Xfanout146 net147 net146 VPWR VGND sg13g2_buf_1
Xfanout157 net158 net157 VPWR VGND sg13g2_buf_1
Xfanout168 net169 net168 VPWR VGND sg13g2_buf_1
Xfanout179 net181 net179 VPWR VGND sg13g2_buf_1
XFILLER_11_601 VPWR VGND sg13g2_decap_8
XFILLER_42_203 VPWR VGND sg13g2_decap_8
Xdigitalen0.g\[1\].u.inv2 VPWR digitalen0.g\[1\].u.OUTP digitalen0.g\[1\].u.OUTN VGND
+ sg13g2_inv_1
XFILLER_10_155 VPWR VGND sg13g2_decap_8
XFILLER_6_137 VPWR VGND sg13g2_decap_8
XFILLER_7_627 VPWR VGND sg13g2_decap_8
XFILLER_2_354 VPWR VGND sg13g2_decap_8
XFILLER_3_844 VPWR VGND sg13g2_decap_8
XFILLER_19_756 VPWR VGND sg13g2_decap_8
XFILLER_19_778 VPWR VGND sg13g2_fill_1
XFILLER_33_214 VPWR VGND sg13g2_decap_8
XFILLER_37_70 VPWR VGND sg13g2_decap_8
XFILLER_46_553 VPWR VGND sg13g2_decap_8
XFILLER_41_280 VPWR VGND sg13g2_decap_8
XFILLER_42_792 VPWR VGND sg13g2_decap_8
X_1960_ net205 VGND VPWR _0292_ state\[36\] clknet_leaf_12_clk sg13g2_dfrbpq_1
X_1891_ net216 VGND VPWR _0223_ daisychain\[95\] clknet_leaf_4_clk sg13g2_dfrbpq_1
X_0911_ VPWR _0072_ state\[4\] VGND sg13g2_inv_1
X_1325_ _0743_ net115 _0437_ _0438_ VPWR VGND sg13g2_a21o_1
X_1256_ net163 VPWR _0386_ VGND net118 state\[25\] sg13g2_o21ai_1
XFILLER_33_39 VPWR VGND sg13g2_decap_8
XFILLER_37_564 VPWR VGND sg13g2_decap_8
X_1187_ _0135_ _0847_ _0848_ net67 _0708_ VPWR VGND sg13g2_a22oi_1
XFILLER_32_291 VPWR VGND sg13g2_decap_4
XFILLER_0_814 VPWR VGND sg13g2_fill_2
XFILLER_0_858 VPWR VGND sg13g2_fill_1
Xdigitalen1.g\[3\].u.inv1 VPWR digitalen1.g\[3\].u.OUTN net7 VGND sg13g2_inv_1
XFILLER_15_236 VPWR VGND sg13g2_decap_8
XFILLER_43_567 VPWR VGND sg13g2_decap_4
XFILLER_7_413 VPWR VGND sg13g2_decap_8
XFILLER_8_925 VPWR VGND sg13g2_fill_2
XFILLER_3_641 VPWR VGND sg13g2_decap_8
XFILLER_2_151 VPWR VGND sg13g2_decap_8
XFILLER_47_840 VPWR VGND sg13g2_decap_8
XFILLER_48_91 VPWR VGND sg13g2_decap_8
X_1110_ VPWR _0779_ daisychain\[78\] VGND sg13g2_inv_1
XFILLER_0_21 VPWR VGND sg13g2_decap_8
XFILLER_0_98 VPWR VGND sg13g2_decap_8
XFILLER_34_567 VPWR VGND sg13g2_fill_1
XFILLER_46_350 VPWR VGND sg13g2_decap_8
X_1041_ VPWR _0710_ daisychain\[9\] VGND sg13g2_inv_1
XFILLER_30_751 VPWR VGND sg13g2_fill_2
XFILLER_30_795 VPWR VGND sg13g2_fill_1
X_1943_ net217 VGND VPWR _0275_ state\[19\] clknet_leaf_11_clk sg13g2_dfrbpq_1
X_1874_ net201 VGND VPWR _0206_ daisychain\[78\] clknet_leaf_2_clk sg13g2_dfrbpq_1
XFILLER_9_74 VPWR VGND sg13g2_decap_8
XFILLER_28_39 VPWR VGND sg13g2_decap_8
XFILLER_38_895 VPWR VGND sg13g2_decap_8
X_1308_ net159 VPWR _0425_ VGND net116 state\[38\] sg13g2_o21ai_1
X_1239_ _0148_ _0886_ _0887_ net64 _0721_ VPWR VGND sg13g2_a22oi_1
XFILLER_12_206 VPWR VGND sg13g2_decap_8
XFILLER_44_49 VPWR VGND sg13g2_decap_8
XFILLER_4_438 VPWR VGND sg13g2_decap_8
XFILLER_0_666 VPWR VGND sg13g2_decap_8
XFILLER_48_637 VPWR VGND sg13g2_decap_8
XFILLER_18_83 VPWR VGND sg13g2_decap_8
XFILLER_43_364 VPWR VGND sg13g2_decap_8
XFILLER_44_876 VPWR VGND sg13g2_decap_8
XFILLER_47_147 VPWR VGND sg13g2_decap_8
XFILLER_11_261 VPWR VGND sg13g2_decap_8
XFILLER_34_60 VPWR VGND sg13g2_decap_8
XFILLER_7_210 VPWR VGND sg13g2_decap_8
XFILLER_7_287 VPWR VGND sg13g2_decap_8
X_1590_ VGND VPWR net96 daisychain\[107\] _0637_ net71 sg13g2_a21oi_1
XFILLER_22_4 VPWR VGND sg13g2_decap_8
XFILLER_38_147 VPWR VGND sg13g2_decap_8
XFILLER_39_615 VPWR VGND sg13g2_decap_8
X_2073_ daisychain\[125\] net31 VPWR VGND sg13g2_buf_1
X_1024_ VPWR _0019_ state\[117\] VGND sg13g2_inv_1
XFILLER_30_18 VPWR VGND sg13g2_decap_8
X_1926_ net223 VGND VPWR _0258_ state\[2\] clknet_leaf_9_clk sg13g2_dfrbpq_1
X_1857_ net191 VGND VPWR _0189_ daisychain\[61\] clknet_leaf_0_clk sg13g2_dfrbpq_1
X_1788_ _0672_ VPWR _0376_ VGND net187 _0023_ sg13g2_o21ai_1
XFILLER_29_125 VPWR VGND sg13g2_decap_8
XFILLER_39_49 VPWR VGND sg13g2_decap_8
XFILLER_13_526 VPWR VGND sg13g2_decap_4
XFILLER_40_301 VPWR VGND sg13g2_decap_8
XFILLER_41_857 VPWR VGND sg13g2_decap_8
XFILLER_20_62 VPWR VGND sg13g2_decap_8
XFILLER_4_235 VPWR VGND sg13g2_decap_8
XFILLER_5_725 VPWR VGND sg13g2_decap_8
XFILLER_0_441 VPWR VGND sg13g2_decap_8
XFILLER_48_434 VPWR VGND sg13g2_decap_8
XFILLER_17_887 VPWR VGND sg13g2_fill_1
XFILLER_32_824 VPWR VGND sg13g2_fill_1
XFILLER_43_161 VPWR VGND sg13g2_decap_8
XFILLER_44_651 VPWR VGND sg13g2_decap_8
XFILLER_45_70 VPWR VGND sg13g2_decap_8
XANTENNA_2 VPWR VGND _0100_ sg13g2_antennanp
XFILLER_6_53 VPWR VGND sg13g2_decap_8
X_1711_ _0441_ VPWR _0299_ VGND net160 _0065_ sg13g2_o21ai_1
X_1642_ VGND VPWR net78 daisychain\[120\] _0676_ net34 sg13g2_a21oi_1
XFILLER_39_401 VPWR VGND sg13g2_decap_8
X_1573_ _0805_ net141 _0623_ _0624_ VPWR VGND sg13g2_a21o_1
XFILLER_26_117 VPWR VGND sg13g2_decap_8
X_2056_ ena net14 VPWR VGND sg13g2_buf_1
X_1007_ VPWR _0001_ state\[100\] VGND sg13g2_inv_1
XFILLER_34_172 VPWR VGND sg13g2_decap_8
XFILLER_41_28 VPWR VGND sg13g2_decap_8
X_1909_ net226 VGND VPWR _0241_ daisychain\[113\] clknet_leaf_7_clk sg13g2_dfrbpq_1
XFILLER_1_238 VPWR VGND sg13g2_decap_8
XFILLER_2_739 VPWR VGND sg13g2_decap_8
XFILLER_18_629 VPWR VGND sg13g2_decap_8
XFILLER_13_323 VPWR VGND sg13g2_decap_4
XFILLER_13_356 VPWR VGND sg13g2_fill_1
XFILLER_14_802 VPWR VGND sg13g2_fill_2
XFILLER_17_139 VPWR VGND sg13g2_decap_8
XFILLER_32_109 VPWR VGND sg13g2_decap_8
XFILLER_41_621 VPWR VGND sg13g2_fill_2
XFILLER_41_676 VPWR VGND sg13g2_decap_8
XFILLER_45_448 VPWR VGND sg13g2_decap_8
XFILLER_9_305 VPWR VGND sg13g2_decap_8
XFILLER_13_378 VPWR VGND sg13g2_fill_2
XFILLER_40_175 VPWR VGND sg13g2_decap_8
XFILLER_41_687 VPWR VGND sg13g2_fill_2
XFILLER_5_522 VPWR VGND sg13g2_decap_8
XFILLER_5_599 VPWR VGND sg13g2_decap_8
XFILLER_48_231 VPWR VGND sg13g2_decap_8
XFILLER_13_890 VPWR VGND sg13g2_fill_2
XFILLER_16_161 VPWR VGND sg13g2_decap_8
XFILLER_20_838 VPWR VGND sg13g2_fill_1
XFILLER_20_849 VPWR VGND sg13g2_decap_8
XFILLER_31_186 VPWR VGND sg13g2_decap_8
XFILLER_32_621 VPWR VGND sg13g2_decap_4
XFILLER_32_632 VPWR VGND sg13g2_fill_2
XFILLER_32_654 VPWR VGND sg13g2_fill_1
XFILLER_32_698 VPWR VGND sg13g2_decap_8
XFILLER_9_861 VPWR VGND sg13g2_decap_8
XFILLER_8_382 VPWR VGND sg13g2_decap_8
X_1625_ _0818_ net143 _0662_ _0663_ VPWR VGND sg13g2_a21o_1
X_1556_ net171 VPWR _0611_ VGND net127 state\[100\] sg13g2_o21ai_1
XFILLER_39_231 VPWR VGND sg13g2_decap_8
X_1487_ _0210_ _0558_ _0559_ net56 _0783_ VPWR VGND sg13g2_a22oi_1
XFILLER_36_39 VPWR VGND sg13g2_decap_8
X_2039_ net228 VGND VPWR _0371_ state\[115\] clknet_leaf_6_clk sg13g2_dfrbpq_1
XFILLER_22_186 VPWR VGND sg13g2_decap_8
XFILLER_6_319 VPWR VGND sg13g2_decap_8
XFILLER_2_536 VPWR VGND sg13g2_decap_8
XFILLER_33_418 VPWR VGND sg13g2_fill_2
XFILLER_45_245 VPWR VGND sg13g2_decap_8
XFILLER_46_735 VPWR VGND sg13g2_decap_8
XFILLER_13_142 VPWR VGND sg13g2_decap_8
XFILLER_26_61 VPWR VGND sg13g2_decap_8
XFILLER_41_451 VPWR VGND sg13g2_decap_8
XFILLER_9_102 VPWR VGND sg13g2_decap_8
XFILLER_5_396 VPWR VGND sg13g2_decap_8
XFILLER_6_853 VPWR VGND sg13g2_decap_8
XFILLER_9_179 VPWR VGND sg13g2_decap_8
X_1410_ VGND VPWR net79 daisychain\[62\] _0502_ net36 sg13g2_a21oi_1
XFILLER_3_32 VPWR VGND sg13g2_decap_8
XFILLER_49_562 VPWR VGND sg13g2_fill_1
X_1341_ _0747_ net117 _0449_ _0450_ VPWR VGND sg13g2_a21o_1
X_1272_ net165 VPWR _0398_ VGND net120 state\[29\] sg13g2_o21ai_1
XFILLER_17_481 VPWR VGND sg13g2_decap_8
XFILLER_36_256 VPWR VGND sg13g2_decap_8
XFILLER_32_462 VPWR VGND sg13g2_fill_2
XFILLER_32_473 VPWR VGND sg13g2_fill_2
X_0987_ VPWR _0106_ state\[80\] VGND sg13g2_inv_1
Xfanout103 net114 net103 VPWR VGND sg13g2_buf_1
Xfanout114 net5 net114 VPWR VGND sg13g2_buf_1
Xfanout125 net129 net125 VPWR VGND sg13g2_buf_1
Xfanout136 net137 net136 VPWR VGND sg13g2_buf_1
Xfanout147 net158 net147 VPWR VGND sg13g2_buf_1
X_1608_ net185 VPWR _0650_ VGND net142 state\[113\] sg13g2_o21ai_1
X_1539_ _0223_ _0597_ _0598_ net62 _0796_ VPWR VGND sg13g2_a22oi_1
XFILLER_47_49 VPWR VGND sg13g2_decap_8
Xfanout158 net4 net158 VPWR VGND sg13g2_buf_1
Xfanout169 net170 net169 VPWR VGND sg13g2_buf_1
XFILLER_10_134 VPWR VGND sg13g2_decap_8
XFILLER_15_429 VPWR VGND sg13g2_decap_8
XFILLER_42_259 VPWR VGND sg13g2_decap_8
XFILLER_43_749 VPWR VGND sg13g2_decap_8
XFILLER_7_606 VPWR VGND sg13g2_decap_8
XFILLER_3_823 VPWR VGND sg13g2_decap_8
XFILLER_6_116 VPWR VGND sg13g2_decap_8
XFILLER_2_333 VPWR VGND sg13g2_decap_8
XFILLER_18_223 VPWR VGND sg13g2_fill_1
XFILLER_18_289 VPWR VGND sg13g2_decap_8
XFILLER_34_727 VPWR VGND sg13g2_fill_1
XFILLER_46_532 VPWR VGND sg13g2_decap_8
XFILLER_14_473 VPWR VGND sg13g2_fill_1
XFILLER_30_911 VPWR VGND sg13g2_decap_8
XFILLER_42_771 VPWR VGND sg13g2_decap_8
X_1890_ net216 VGND VPWR _0222_ daisychain\[94\] clknet_leaf_4_clk sg13g2_dfrbpq_1
X_0910_ VPWR _0061_ state\[3\] VGND sg13g2_inv_1
XFILLER_5_193 VPWR VGND sg13g2_decap_8
XFILLER_37_510 VPWR VGND sg13g2_fill_2
XFILLER_37_521 VPWR VGND sg13g2_fill_1
X_1324_ net159 VPWR _0437_ VGND net115 state\[42\] sg13g2_o21ai_1
X_1255_ _0152_ _0384_ _0385_ net53 _0725_ VPWR VGND sg13g2_a22oi_1
X_1186_ VGND VPWR net94 daisychain\[6\] _0848_ net67 sg13g2_a21oi_1
XFILLER_33_18 VPWR VGND sg13g2_decap_8
XFILLER_20_443 VPWR VGND sg13g2_decap_8
Xdigitalen1.g\[3\].u.inv2 VPWR digitalen1.g\[3\].u.OUTP digitalen1.g\[3\].u.OUTN VGND
+ sg13g2_inv_1
XFILLER_0_837 VPWR VGND sg13g2_decap_8
XFILLER_47_329 VPWR VGND sg13g2_decap_8
XFILLER_15_215 VPWR VGND sg13g2_decap_8
XFILLER_43_546 VPWR VGND sg13g2_decap_8
XFILLER_11_432 VPWR VGND sg13g2_decap_8
XFILLER_12_922 VPWR VGND sg13g2_decap_4
XFILLER_8_904 VPWR VGND sg13g2_decap_8
XFILLER_2_130 VPWR VGND sg13g2_decap_8
XFILLER_3_620 VPWR VGND sg13g2_decap_8
XFILLER_3_697 VPWR VGND sg13g2_decap_8
XFILLER_7_469 VPWR VGND sg13g2_decap_8
XFILLER_24_8 VPWR VGND sg13g2_fill_1
XFILLER_48_70 VPWR VGND sg13g2_decap_8
X_1040_ VPWR _0709_ daisychain\[8\] VGND sg13g2_inv_1
XFILLER_0_77 VPWR VGND sg13g2_decap_8
XFILLER_14_292 VPWR VGND sg13g2_decap_8
XFILLER_15_771 VPWR VGND sg13g2_fill_2
XFILLER_15_782 VPWR VGND sg13g2_fill_1
XFILLER_19_598 VPWR VGND sg13g2_decap_8
XFILLER_47_896 VPWR VGND sg13g2_decap_8
X_1942_ net224 VGND VPWR _0274_ state\[18\] clknet_leaf_8_clk sg13g2_dfrbpq_1
XFILLER_9_53 VPWR VGND sg13g2_decap_8
XFILLER_6_480 VPWR VGND sg13g2_decap_8
X_1873_ net201 VGND VPWR _0205_ daisychain\[77\] clknet_leaf_2_clk sg13g2_dfrbpq_1
XFILLER_28_18 VPWR VGND sg13g2_decap_8
XFILLER_43_0 VPWR VGND sg13g2_decap_8
XFILLER_13_708 VPWR VGND sg13g2_fill_2
XFILLER_37_351 VPWR VGND sg13g2_decap_8
XFILLER_38_841 VPWR VGND sg13g2_decap_8
XFILLER_44_28 VPWR VGND sg13g2_decap_8
X_1307_ _0165_ _0423_ _0424_ net50 _0738_ VPWR VGND sg13g2_a22oi_1
X_1238_ VGND VPWR net92 daisychain\[19\] _0887_ net64 sg13g2_a21oi_1
X_1169_ _0704_ net135 _0834_ _0835_ VPWR VGND sg13g2_a21o_1
XFILLER_4_417 VPWR VGND sg13g2_decap_8
XFILLER_5_907 VPWR VGND sg13g2_decap_8
XFILLER_0_645 VPWR VGND sg13g2_decap_8
XFILLER_18_62 VPWR VGND sg13g2_decap_8
XFILLER_47_126 VPWR VGND sg13g2_decap_8
XFILLER_48_616 VPWR VGND sg13g2_decap_8
XFILLER_16_546 VPWR VGND sg13g2_decap_8
XFILLER_43_343 VPWR VGND sg13g2_decap_8
XFILLER_44_855 VPWR VGND sg13g2_decap_8
XFILLER_11_240 VPWR VGND sg13g2_decap_8
XFILLER_12_741 VPWR VGND sg13g2_decap_4
XFILLER_7_266 VPWR VGND sg13g2_decap_8
XFILLER_8_734 VPWR VGND sg13g2_decap_8
XFILLER_3_494 VPWR VGND sg13g2_decap_8
XFILLER_38_126 VPWR VGND sg13g2_decap_8
XFILLER_47_693 VPWR VGND sg13g2_decap_8
X_2072_ daisychain\[124\] net30 VPWR VGND sg13g2_buf_1
X_1023_ VPWR _0018_ state\[116\] VGND sg13g2_inv_1
XFILLER_30_571 VPWR VGND sg13g2_decap_8
XFILLER_34_398 VPWR VGND sg13g2_fill_2
X_1925_ net222 VGND VPWR _0257_ state\[1\] clknet_leaf_9_clk sg13g2_dfrbpq_1
X_1856_ net191 VGND VPWR _0188_ daisychain\[60\] clknet_leaf_0_clk sg13g2_dfrbpq_1
X_1787_ _0669_ VPWR _0375_ VGND net187 _0021_ sg13g2_o21ai_1
XFILLER_29_104 VPWR VGND sg13g2_decap_8
XFILLER_39_28 VPWR VGND sg13g2_decap_8
XFILLER_41_836 VPWR VGND sg13g2_decap_8
XFILLER_40_357 VPWR VGND sg13g2_decap_8
XFILLER_4_214 VPWR VGND sg13g2_decap_8
XFILLER_5_704 VPWR VGND sg13g2_decap_8
XFILLER_0_420 VPWR VGND sg13g2_decap_8
XFILLER_1_921 VPWR VGND sg13g2_decap_4
XFILLER_0_497 VPWR VGND sg13g2_decap_8
XFILLER_29_83 VPWR VGND sg13g2_decap_8
XFILLER_44_630 VPWR VGND sg13g2_decap_8
XFILLER_48_413 VPWR VGND sg13g2_decap_8
XFILLER_12_571 VPWR VGND sg13g2_decap_8
XFILLER_12_582 VPWR VGND sg13g2_fill_1
XFILLER_43_140 VPWR VGND sg13g2_decap_8
XANTENNA_3 VPWR VGND state\[52\] sg13g2_antennanp
XFILLER_6_32 VPWR VGND sg13g2_decap_8
X_1710_ _0438_ VPWR _0298_ VGND net160 _0064_ sg13g2_o21ai_1
X_1641_ _0822_ net100 _0674_ _0675_ VPWR VGND sg13g2_a21o_1
X_1572_ net184 VPWR _0623_ VGND net141 state\[104\] sg13g2_o21ai_1
XFILLER_3_291 VPWR VGND sg13g2_decap_8
XFILLER_4_781 VPWR VGND sg13g2_decap_8
XFILLER_34_151 VPWR VGND sg13g2_decap_8
XFILLER_35_652 VPWR VGND sg13g2_decap_8
XFILLER_47_490 VPWR VGND sg13g2_decap_8
X_2055_ ena net13 VPWR VGND sg13g2_buf_1
X_1006_ VPWR _0126_ state\[99\] VGND sg13g2_inv_1
XFILLER_30_390 VPWR VGND sg13g2_fill_1
X_1908_ net229 VGND VPWR _0240_ daisychain\[112\] clknet_leaf_7_clk sg13g2_dfrbpq_1
X_1839_ net204 VGND VPWR _0171_ daisychain\[43\] clknet_leaf_12_clk sg13g2_dfrbpq_1
XFILLER_1_217 VPWR VGND sg13g2_decap_8
XFILLER_2_718 VPWR VGND sg13g2_decap_8
XFILLER_17_118 VPWR VGND sg13g2_decap_8
XFILLER_38_490 VPWR VGND sg13g2_decap_8
XFILLER_45_427 VPWR VGND sg13g2_decap_8
XFILLER_46_917 VPWR VGND sg13g2_decap_8
XFILLER_15_96 VPWR VGND sg13g2_decap_8
XFILLER_25_195 VPWR VGND sg13g2_decap_8
XFILLER_40_154 VPWR VGND sg13g2_decap_8
XFILLER_41_600 VPWR VGND sg13g2_decap_8
XFILLER_41_655 VPWR VGND sg13g2_fill_2
XFILLER_31_95 VPWR VGND sg13g2_decap_8
XFILLER_5_501 VPWR VGND sg13g2_decap_8
XFILLER_5_578 VPWR VGND sg13g2_decap_8
XFILLER_0_294 VPWR VGND sg13g2_decap_8
XFILLER_1_795 VPWR VGND sg13g2_decap_8
XFILLER_48_210 VPWR VGND sg13g2_decap_8
XFILLER_49_722 VPWR VGND sg13g2_decap_8
XFILLER_16_140 VPWR VGND sg13g2_decap_8
XFILLER_48_287 VPWR VGND sg13g2_decap_8
XFILLER_49_788 VPWR VGND sg13g2_decap_8
XFILLER_12_390 VPWR VGND sg13g2_fill_1
XFILLER_31_165 VPWR VGND sg13g2_decap_8
XFILLER_8_361 VPWR VGND sg13g2_decap_8
X_1624_ net186 VPWR _0662_ VGND net143 state\[117\] sg13g2_o21ai_1
X_1555_ _0227_ _0609_ _0610_ net60 _0800_ VPWR VGND sg13g2_a22oi_1
XFILLER_36_18 VPWR VGND sg13g2_decap_8
XFILLER_39_210 VPWR VGND sg13g2_decap_8
XFILLER_39_287 VPWR VGND sg13g2_decap_8
X_1486_ VGND VPWR net90 daisychain\[81\] _0559_ net56 sg13g2_a21oi_1
XFILLER_10_316 VPWR VGND sg13g2_decap_8
XFILLER_11_828 VPWR VGND sg13g2_fill_1
XFILLER_11_839 VPWR VGND sg13g2_fill_1
XFILLER_22_165 VPWR VGND sg13g2_decap_8
X_2038_ net228 VGND VPWR _0370_ state\[114\] clknet_leaf_6_clk sg13g2_dfrbpq_1
XFILLER_2_515 VPWR VGND sg13g2_decap_8
XFILLER_18_405 VPWR VGND sg13g2_decap_8
XFILLER_26_40 VPWR VGND sg13g2_decap_8
XFILLER_45_224 VPWR VGND sg13g2_decap_8
XFILLER_46_714 VPWR VGND sg13g2_decap_8
XFILLER_13_121 VPWR VGND sg13g2_decap_8
XFILLER_13_198 VPWR VGND sg13g2_decap_8
XFILLER_41_430 VPWR VGND sg13g2_decap_8
XFILLER_6_821 VPWR VGND sg13g2_decap_8
XFILLER_9_158 VPWR VGND sg13g2_decap_8
XFILLER_3_11 VPWR VGND sg13g2_decap_8
XFILLER_47_7 VPWR VGND sg13g2_decap_8
XFILLER_5_375 VPWR VGND sg13g2_decap_8
X_1340_ net161 VPWR _0449_ VGND net117 state\[46\] sg13g2_o21ai_1
XFILLER_1_592 VPWR VGND sg13g2_decap_8
XFILLER_36_235 VPWR VGND sg13g2_decap_8
XFILLER_37_758 VPWR VGND sg13g2_decap_8
XFILLER_3_88 VPWR VGND sg13g2_decap_8
XFILLER_49_541 VPWR VGND sg13g2_decap_8
X_1271_ _0156_ _0396_ _0397_ net53 _0729_ VPWR VGND sg13g2_a22oi_1
XFILLER_37_769 VPWR VGND sg13g2_decap_8
XFILLER_45_791 VPWR VGND sg13g2_decap_8
Xclkbuf_leaf_8_clk clknet_2_2__leaf_clk clknet_leaf_8_clk VPWR VGND sg13g2_buf_8
X_0986_ VPWR _0104_ state\[79\] VGND sg13g2_inv_1
XFILLER_47_28 VPWR VGND sg13g2_decap_8
Xfanout104 net105 net104 VPWR VGND sg13g2_buf_1
Xfanout115 net117 net115 VPWR VGND sg13g2_buf_1
Xfanout126 net127 net126 VPWR VGND sg13g2_buf_1
Xfanout137 net138 net137 VPWR VGND sg13g2_buf_1
Xfanout148 net152 net148 VPWR VGND sg13g2_buf_1
Xfanout159 net162 net159 VPWR VGND sg13g2_buf_1
X_1607_ _0240_ _0648_ _0649_ net76 _0813_ VPWR VGND sg13g2_a22oi_1
X_1538_ VGND VPWR net89 daisychain\[94\] _0598_ net62 sg13g2_a21oi_1
X_1469_ _0779_ net113 _0545_ _0546_ VPWR VGND sg13g2_a21o_1
XFILLER_43_728 VPWR VGND sg13g2_decap_8
XFILLER_10_113 VPWR VGND sg13g2_decap_8
XFILLER_12_20 VPWR VGND sg13g2_decap_8
XFILLER_42_238 VPWR VGND sg13g2_decap_8
XFILLER_12_42 VPWR VGND sg13g2_fill_1
XFILLER_2_312 VPWR VGND sg13g2_decap_8
XFILLER_3_802 VPWR VGND sg13g2_decap_8
XFILLER_3_879 VPWR VGND sg13g2_decap_8
XFILLER_18_202 VPWR VGND sg13g2_decap_8
XFILLER_19_736 VPWR VGND sg13g2_decap_8
XFILLER_2_389 VPWR VGND sg13g2_decap_8
XFILLER_46_511 VPWR VGND sg13g2_decap_8
XFILLER_18_257 VPWR VGND sg13g2_fill_2
XFILLER_42_750 VPWR VGND sg13g2_decap_8
XFILLER_46_588 VPWR VGND sg13g2_decap_8
XFILLER_5_172 VPWR VGND sg13g2_decap_8
XFILLER_6_684 VPWR VGND sg13g2_decap_4
XFILLER_6_695 VPWR VGND sg13g2_decap_8
X_1323_ _0169_ _0435_ _0436_ net49 _0742_ VPWR VGND sg13g2_a22oi_1
XFILLER_18_780 VPWR VGND sg13g2_decap_8
XFILLER_49_382 VPWR VGND sg13g2_decap_8
XFILLER_49_393 VPWR VGND sg13g2_fill_2
X_1254_ VGND VPWR net85 daisychain\[23\] _0385_ net53 sg13g2_a21oi_1
X_1185_ _0708_ net133 _0846_ _0847_ VPWR VGND sg13g2_a21o_1
XFILLER_40_709 VPWR VGND sg13g2_fill_2
XFILLER_3_109 VPWR VGND sg13g2_decap_8
X_0969_ VPWR _0086_ state\[62\] VGND sg13g2_inv_1
XFILLER_0_816 VPWR VGND sg13g2_fill_1
XFILLER_47_308 VPWR VGND sg13g2_decap_8
XFILLER_30_219 VPWR VGND sg13g2_decap_4
XFILLER_43_525 VPWR VGND sg13g2_decap_8
XFILLER_11_477 VPWR VGND sg13g2_decap_4
XFILLER_23_41 VPWR VGND sg13g2_decap_8
XFILLER_23_96 VPWR VGND sg13g2_decap_8
XFILLER_7_448 VPWR VGND sg13g2_decap_8
XFILLER_2_186 VPWR VGND sg13g2_decap_8
XFILLER_3_676 VPWR VGND sg13g2_decap_8
XFILLER_0_56 VPWR VGND sg13g2_decap_8
XFILLER_38_308 VPWR VGND sg13g2_decap_8
XFILLER_46_385 VPWR VGND sg13g2_decap_8
XFILLER_47_875 VPWR VGND sg13g2_decap_8
XFILLER_14_271 VPWR VGND sg13g2_decap_8
XFILLER_15_750 VPWR VGND sg13g2_fill_2
XFILLER_21_208 VPWR VGND sg13g2_fill_1
XFILLER_30_720 VPWR VGND sg13g2_fill_1
XFILLER_9_32 VPWR VGND sg13g2_decap_8
X_1941_ net224 VGND VPWR _0273_ state\[17\] clknet_leaf_8_clk sg13g2_dfrbpq_1
X_1872_ net200 VGND VPWR _0204_ daisychain\[76\] clknet_leaf_2_clk sg13g2_dfrbpq_1
XFILLER_38_820 VPWR VGND sg13g2_decap_8
X_1306_ VGND VPWR net87 daisychain\[36\] _0424_ net50 sg13g2_a21oi_1
X_1237_ _0721_ net130 _0885_ _0886_ VPWR VGND sg13g2_a21o_1
X_1168_ net178 VPWR _0834_ VGND net133 state\[3\] sg13g2_o21ai_1
X_1099_ VPWR _0768_ daisychain\[67\] VGND sg13g2_inv_1
XFILLER_20_252 VPWR VGND sg13g2_fill_2
XFILLER_40_539 VPWR VGND sg13g2_decap_8
XFILLER_0_624 VPWR VGND sg13g2_decap_8
XFILLER_44_834 VPWR VGND sg13g2_decap_8
XFILLER_47_105 VPWR VGND sg13g2_decap_8
XFILLER_12_764 VPWR VGND sg13g2_fill_2
XFILLER_31_528 VPWR VGND sg13g2_decap_4
XFILLER_34_95 VPWR VGND sg13g2_decap_8
XFILLER_43_322 VPWR VGND sg13g2_decap_8
XFILLER_43_399 VPWR VGND sg13g2_decap_8
XFILLER_11_296 VPWR VGND sg13g2_decap_8
XFILLER_7_245 VPWR VGND sg13g2_decap_8
XFILLER_38_105 VPWR VGND sg13g2_decap_8
XFILLER_3_473 VPWR VGND sg13g2_decap_8
XFILLER_34_322 VPWR VGND sg13g2_decap_8
XFILLER_35_823 VPWR VGND sg13g2_decap_8
XFILLER_46_182 VPWR VGND sg13g2_decap_8
XFILLER_47_672 VPWR VGND sg13g2_decap_8
X_2071_ daisychain\[123\] net29 VPWR VGND sg13g2_buf_1
X_1022_ VPWR _0017_ state\[115\] VGND sg13g2_inv_1
X_1924_ net222 VGND VPWR _0256_ state\[0\] clknet_leaf_9_clk sg13g2_dfrbpq_1
X_1855_ net193 VGND VPWR _0187_ daisychain\[59\] clknet_leaf_0_clk sg13g2_dfrbpq_1
X_1786_ _0666_ VPWR _0374_ VGND net186 _0020_ sg13g2_o21ai_1
XFILLER_44_119 VPWR VGND sg13g2_decap_8
XFILLER_45_609 VPWR VGND sg13g2_decap_8
XFILLER_37_182 VPWR VGND sg13g2_decap_8
XFILLER_40_336 VPWR VGND sg13g2_decap_8
XFILLER_41_815 VPWR VGND sg13g2_decap_8
XFILLER_20_20 VPWR VGND sg13g2_fill_2
XFILLER_0_476 VPWR VGND sg13g2_decap_8
XFILLER_1_900 VPWR VGND sg13g2_decap_8
XFILLER_20_97 VPWR VGND sg13g2_decap_8
XFILLER_29_62 VPWR VGND sg13g2_decap_8
XFILLER_49_926 VPWR VGND sg13g2_fill_1
XFILLER_16_344 VPWR VGND sg13g2_fill_2
XFILLER_17_856 VPWR VGND sg13g2_decap_8
XFILLER_28_182 VPWR VGND sg13g2_decap_8
XFILLER_48_469 VPWR VGND sg13g2_decap_8
XFILLER_40_892 VPWR VGND sg13g2_decap_8
XFILLER_43_196 VPWR VGND sg13g2_decap_8
XFILLER_44_686 VPWR VGND sg13g2_decap_8
XFILLER_3_270 VPWR VGND sg13g2_decap_8
XFILLER_4_760 VPWR VGND sg13g2_decap_8
XFILLER_6_11 VPWR VGND sg13g2_decap_8
XFILLER_6_88 VPWR VGND sg13g2_decap_8
X_1640_ net146 VPWR _0674_ VGND net100 state\[121\] sg13g2_o21ai_1
X_1571_ _0231_ _0621_ _0622_ net72 _0804_ VPWR VGND sg13g2_a22oi_1
XFILLER_34_130 VPWR VGND sg13g2_decap_8
X_2054_ ena net12 VPWR VGND sg13g2_buf_1
X_1005_ VPWR _0125_ state\[98\] VGND sg13g2_inv_1
XFILLER_10_509 VPWR VGND sg13g2_decap_8
XFILLER_30_380 VPWR VGND sg13g2_decap_8
X_1907_ net227 VGND VPWR _0239_ daisychain\[111\] clknet_leaf_7_clk sg13g2_dfrbpq_1
X_1838_ net204 VGND VPWR _0170_ daisychain\[42\] clknet_leaf_12_clk sg13g2_dfrbpq_1
X_1769_ _0615_ VPWR _0357_ VGND net171 _0002_ sg13g2_o21ai_1
XFILLER_38_480 VPWR VGND sg13g2_fill_1
XFILLER_45_406 VPWR VGND sg13g2_decap_8
XFILLER_25_174 VPWR VGND sg13g2_decap_8
XFILLER_40_133 VPWR VGND sg13g2_decap_8
XFILLER_31_74 VPWR VGND sg13g2_decap_8
XFILLER_5_557 VPWR VGND sg13g2_decap_8
Xoutput30 net30 uo_out[4] VPWR VGND sg13g2_buf_1
XFILLER_0_273 VPWR VGND sg13g2_decap_8
XFILLER_1_774 VPWR VGND sg13g2_decap_8
XFILLER_48_266 VPWR VGND sg13g2_decap_8
XFILLER_49_701 VPWR VGND sg13g2_decap_8
XFILLER_49_767 VPWR VGND sg13g2_decap_8
XFILLER_16_196 VPWR VGND sg13g2_decap_8
XFILLER_17_653 VPWR VGND sg13g2_decap_8
XFILLER_17_664 VPWR VGND sg13g2_fill_2
XFILLER_32_634 VPWR VGND sg13g2_fill_1
XFILLER_32_645 VPWR VGND sg13g2_decap_8
XFILLER_36_439 VPWR VGND sg13g2_decap_8
XFILLER_44_483 VPWR VGND sg13g2_decap_8
XFILLER_13_892 VPWR VGND sg13g2_fill_1
XFILLER_31_144 VPWR VGND sg13g2_decap_8
XFILLER_8_340 VPWR VGND sg13g2_decap_8
X_1623_ _0244_ _0660_ _0661_ net74 _0817_ VPWR VGND sg13g2_a22oi_1
X_1554_ VGND VPWR net88 daisychain\[98\] _0610_ net61 sg13g2_a21oi_1
X_1485_ _0783_ net125 _0557_ _0558_ VPWR VGND sg13g2_a21o_1
.ends

** sch_path: /home/cmaier/EDA/PUDDING/xschem/dac4x32module.sch
.subckt dac4x32module VDD EN[15] EN[14] EN[13] EN[12] EN[11] EN[10] EN[9] EN[8] EN[7] EN[6] EN[5] EN[4] EN[3] EN[2] EN[1] EN[0]
+ ENB[15] ENB[14] ENB[13] ENB[12] ENB[11] ENB[10] ENB[9] ENB[8] ENB[7] ENB[6] ENB[5] ENB[4] ENB[3] ENB[2] ENB[1] ENB[0] ON[127] ON[126]
+ ON[125] ON[124] ON[123] ON[122] ON[121] ON[120] ON[119] ON[118] ON[117] ON[116] ON[115] ON[114] ON[113] ON[112] ON[111] ON[110] ON[109]
+ ON[108] ON[107] ON[106] ON[105] ON[104] ON[103] ON[102] ON[101] ON[100] ON[99] ON[98] ON[97] ON[96] ON[95] ON[94] ON[93] ON[92] ON[91]
+ ON[90] ON[89] ON[88] ON[87] ON[86] ON[85] ON[84] ON[83] ON[82] ON[81] ON[80] ON[79] ON[78] ON[77] ON[76] ON[75] ON[74] ON[73] ON[72]
+ ON[71] ON[70] ON[69] ON[68] ON[67] ON[66] ON[65] ON[64] ON[63] ON[62] ON[61] ON[60] ON[59] ON[58] ON[57] ON[56] ON[55] ON[54] ON[53]
+ ON[52] ON[51] ON[50] ON[49] ON[48] ON[47] ON[46] ON[45] ON[44] ON[43] ON[42] ON[41] ON[40] ON[39] ON[38] ON[37] ON[36] ON[35] ON[34]
+ ON[33] ON[32] ON[31] ON[30] ON[29] ON[28] ON[27] ON[26] ON[25] ON[24] ON[23] ON[22] ON[21] ON[20] ON[19] ON[18] ON[17] ON[16] ON[15]
+ ON[14] ON[13] ON[12] ON[11] ON[10] ON[9] ON[8] ON[7] ON[6] ON[5] ON[4] ON[3] ON[2] ON[1] ON[0] ONB[127] ONB[126] ONB[125] ONB[124]
+ ONB[123] ONB[122] ONB[121] ONB[120] ONB[119] ONB[118] ONB[117] ONB[116] ONB[115] ONB[114] ONB[113] ONB[112] ONB[111] ONB[110] ONB[109]
+ ONB[108] ONB[107] ONB[106] ONB[105] ONB[104] ONB[103] ONB[102] ONB[101] ONB[100] ONB[99] ONB[98] ONB[97] ONB[96] ONB[95] ONB[94] ONB[93]
+ ONB[92] ONB[91] ONB[90] ONB[89] ONB[88] ONB[87] ONB[86] ONB[85] ONB[84] ONB[83] ONB[82] ONB[81] ONB[80] ONB[79] ONB[78] ONB[77] ONB[76]
+ ONB[75] ONB[74] ONB[73] ONB[72] ONB[71] ONB[70] ONB[69] ONB[68] ONB[67] ONB[66] ONB[65] ONB[64] ONB[63] ONB[62] ONB[61] ONB[60] ONB[59]
+ ONB[58] ONB[57] ONB[56] ONB[55] ONB[54] ONB[53] ONB[52] ONB[51] ONB[50] ONB[49] ONB[48] ONB[47] ONB[46] ONB[45] ONB[44] ONB[43] ONB[42]
+ ONB[41] ONB[40] ONB[39] ONB[38] ONB[37] ONB[36] ONB[35] ONB[34] ONB[33] ONB[32] ONB[31] ONB[30] ONB[29] ONB[28] ONB[27] ONB[26] ONB[25]
+ ONB[24] ONB[23] ONB[22] ONB[21] ONB[20] ONB[19] ONB[18] ONB[17] ONB[16] ONB[15] ONB[14] ONB[13] ONB[12] ONB[11] ONB[10] ONB[9] ONB[8]
+ ONB[7] ONB[6] ONB[5] ONB[4] ONB[3] ONB[2] ONB[1] ONB[0] Iout VbiasP[7] VbiasP[6] VbiasP[5] VbiasP[4] VbiasP[3] VbiasP[2] VbiasP[1]
+ VbiasP[0] VSS
*.PININFO Iout:B ON[127:0]:I ONB[127:0]:I VSS:B VDD:B VbiasP[7:0]:B EN[15:0]:I ENB[15:0]:I
xdac3 VDD EN[6] EN[7] ENB[6] ENB[7] ON[79] ON[78] ON[77] ON[76] ON[75] ON[74] ON[73] ON[72] ON[71] ON[70] ON[69] ON[68] ON[67]
+ ON[66] ON[65] ON[64] ON[48] ON[49] ON[50] ON[51] ON[52] ON[53] ON[54] ON[55] ON[56] ON[57] ON[58] ON[59] ON[60] ON[61] ON[62] ON[63]
+ ONB[48] ONB[49] ONB[50] ONB[51] ONB[52] ONB[53] ONB[54] ONB[55] ONB[56] ONB[57] ONB[58] ONB[59] ONB[60] ONB[61] ONB[62] ONB[63] ENB[9]
+ ENB[8] ONB[79] ONB[78] ONB[77] ONB[76] ONB[75] ONB[74] ONB[73] ONB[72] ONB[71] ONB[70] ONB[69] ONB[68] ONB[67] ONB[66] ONB[65] ONB[64]
+ EN[9] EN[8] Iout VbiasP[4] VbiasP[3] bias[4] bias[3] VSS dac2u32out4in
xdac2 VDD EN[4] EN[5] ENB[4] ENB[5] ON[95] ON[94] ON[93] ON[92] ON[91] ON[90] ON[89] ON[88] ON[87] ON[86] ON[85] ON[84] ON[83]
+ ON[82] ON[81] ON[80] ON[32] ON[33] ON[34] ON[35] ON[36] ON[37] ON[38] ON[39] ON[40] ON[41] ON[42] ON[43] ON[44] ON[45] ON[46] ON[47]
+ ONB[32] ONB[33] ONB[34] ONB[35] ONB[36] ONB[37] ONB[38] ONB[39] ONB[40] ONB[41] ONB[42] ONB[43] ONB[44] ONB[45] ONB[46] ONB[47] ENB[11]
+ ENB[10] ONB[95] ONB[94] ONB[93] ONB[92] ONB[91] ONB[90] ONB[89] ONB[88] ONB[87] ONB[86] ONB[85] ONB[84] ONB[83] ONB[82] ONB[81] ONB[80]
+ EN[11] EN[10] Iout VbiasP[5] VbiasP[2] bias[5] bias[2] VSS dac2u32out4in
xdac0 VDD EN[1] EN[0] ENB[1] ENB[0] ON[127] ON[126] ON[125] ON[124] ON[123] ON[122] ON[121] ON[120] ON[119] ON[118] ON[117]
+ ON[116] ON[115] ON[114] ON[113] ON[112] ON[0] ON[1] ON[2] ON[3] ON[4] ON[5] ON[6] ON[7] ON[8] ON[9] ON[10] ON[11] ON[12] ON[13] ON[14]
+ ON[15] ONB[0] ONB[1] ONB[2] ONB[3] ONB[4] ONB[5] ONB[6] ONB[7] ONB[8] ONB[9] ONB[10] ONB[11] ONB[12] ONB[13] ONB[14] ONB[15] ENB[15]
+ ENB[14] ONB[127] ONB[126] ONB[125] ONB[124] ONB[123] ONB[122] ONB[121] ONB[120] ONB[119] ONB[118] ONB[117] ONB[116] ONB[115] ONB[114]
+ ONB[113] ONB[112] EN[15] EN[14] Iout VbiasP[7] VbiasP[0] bias[7] bias[0] VSS dac2u32out4in
xdac1 VDD EN[2] EN[3] ENB[2] ENB[3] ON[111] ON[110] ON[109] ON[108] ON[107] ON[106] ON[105] ON[104] ON[103] ON[102] ON[101]
+ ON[100] ON[99] ON[98] ON[97] ON[96] ON[16] ON[17] ON[18] ON[19] ON[20] ON[21] ON[22] ON[23] ON[24] ON[25] ON[26] ON[27] ON[28] ON[29]
+ ON[30] ON[31] ONB[16] ONB[17] ONB[18] ONB[19] ONB[20] ONB[21] ONB[22] ONB[23] ONB[24] ONB[25] ONB[26] ONB[27] ONB[28] ONB[29] ONB[30]
+ ONB[31] ENB[13] ENB[12] ONB[111] ONB[110] ONB[109] ONB[108] ONB[107] ONB[106] ONB[105] ONB[104] ONB[103] ONB[102] ONB[101] ONB[100]
+ ONB[99] ONB[98] ONB[97] ONB[96] EN[13] EN[12] Iout VbiasP[6] VbiasP[1] bias[6] bias[1] VSS dac2u32out4in
xb32 VDD VbiasP[4] VbiasP[5] bias[5] bias[4] VbiasP[3] VbiasP[2] bias[2] bias[3] dacbuffer
xb21 VDD VbiasP[5] VbiasP[6] bias[6] bias[5] VbiasP[2] VbiasP[1] bias[1] bias[2] dacbuffer
xb10 VDD VbiasP[6] VbiasP[7] bias[7] bias[6] VbiasP[1] VbiasP[0] bias[0] bias[1] dacbuffer
xb3 VDD VbiasP[4] bias[4] bias[3] VbiasP[3] dacendbuffer
xb0 VDD VbiasP[7] bias[7] bias[0] VbiasP[0] dacendbuffer
.ends

* expanding   symbol:  dac2u32out4in.sym # of pins=13
** sym_path: /home/cmaier/EDA/PUDDING/xschem/dac2u32out4in.sym
** sch_path: /home/cmaier/EDA/PUDDING/xschem/dac2u32out4in.sch
.subckt dac2u32out4in VDD EN[1] EN[0] ENB[1] ENB[0] ON[31] ON[30] ON[29] ON[28] ON[27] ON[26] ON[25] ON[24] ON[23] ON[22] ON[21]
+ ON[20] ON[19] ON[18] ON[17] ON[16] ON[15] ON[14] ON[13] ON[12] ON[11] ON[10] ON[9] ON[8] ON[7] ON[6] ON[5] ON[4] ON[3] ON[2] ON[1] ON[0]
+ ONB[15] ONB[14] ONB[13] ONB[12] ONB[11] ONB[10] ONB[9] ONB[8] ONB[7] ONB[6] ONB[5] ONB[4] ONB[3] ONB[2] ONB[1] ONB[0] ENB[3] ENB[2]
+ ONB[31] ONB[30] ONB[29] ONB[28] ONB[27] ONB[26] ONB[25] ONB[24] ONB[23] ONB[22] ONB[21] ONB[20] ONB[19] ONB[18] ONB[17] ONB[16] EN[3]
+ EN[2] Iout Vpcbias[1] Vpcbias[0] Vpbias[1] Vpbias[0] VSS
*.PININFO Iout:B ON[15:0]:I ONB[15:0]:I VSS:B VDD:B Vpcbias[1:0]:B EN[1:0]:I ENB[1:0]:I ON[31:16]:I ONB[31:16]:I EN[3:2]:I
*+ ENB[3:2]:I Vpbias[1:0]:B
Mcbias[0] Vpcbias[0] Vpcbias[0] Vpbias[0] VDD sg13_lv_pmos w=5.85u l=0.15u ng=1 m=2
xref[1] VDD Vpbias[0] EN[1] ENB[1] Vpbias[0] Vpcbias[0] VSS unitsource2u
xref[0] VDD Vpbias[0] EN[0] ENB[0] Vpbias[0] Vpcbias[0] VSS unitsource2u
xsrc[15] VDD Vpbias[0] ON[15] ONB[15] Iout Vpcbias[0] VSS unitsource2u
xsrc[14] VDD Vpbias[0] ON[14] ONB[14] Iout Vpcbias[0] VSS unitsource2u
xsrc[13] VDD Vpbias[0] ON[13] ONB[13] Iout Vpcbias[0] VSS unitsource2u
xsrc[12] VDD Vpbias[0] ON[12] ONB[12] Iout Vpcbias[0] VSS unitsource2u
xsrc[11] VDD Vpbias[0] ON[11] ONB[11] Iout Vpcbias[0] VSS unitsource2u
xsrc[10] VDD Vpbias[0] ON[10] ONB[10] Iout Vpcbias[0] VSS unitsource2u
xsrc[9] VDD Vpbias[0] ON[9] ONB[9] Iout Vpcbias[0] VSS unitsource2u
xsrc[8] VDD Vpbias[0] ON[8] ONB[8] Iout Vpcbias[0] VSS unitsource2u
xsrc[7] VDD Vpbias[0] ON[7] ONB[7] Iout Vpcbias[0] VSS unitsource2u
xsrc[6] VDD Vpbias[0] ON[6] ONB[6] Iout Vpcbias[0] VSS unitsource2u
xsrc[5] VDD Vpbias[0] ON[5] ONB[5] Iout Vpcbias[0] VSS unitsource2u
xsrc[4] VDD Vpbias[0] ON[4] ONB[4] Iout Vpcbias[0] VSS unitsource2u
xsrc[3] VDD Vpbias[0] ON[3] ONB[3] Iout Vpcbias[0] VSS unitsource2u
xsrc[2] VDD Vpbias[0] ON[2] ONB[2] Iout Vpcbias[0] VSS unitsource2u
xsrc[1] VDD Vpbias[0] ON[1] ONB[1] Iout Vpcbias[0] VSS unitsource2u
xsrc[0] VDD Vpbias[0] ON[0] ONB[0] Iout Vpcbias[0] VSS unitsource2u
Mcbias[1] Vpcbias[1] Vpcbias[1] Vpbias[1] VDD sg13_lv_pmos w=5.85u l=0.15u ng=1 m=2
xref[3] VDD Vpbias[1] EN[3] ENB[3] Vpbias[1] Vpcbias[1] VSS unitsource2u
xref[2] VDD Vpbias[1] EN[2] ENB[2] Vpbias[1] Vpcbias[1] VSS unitsource2u
xsrc[31] VDD Vpbias[1] ON[31] ONB[31] Iout Vpcbias[1] VSS unitsource2u
xsrc[30] VDD Vpbias[1] ON[30] ONB[30] Iout Vpcbias[1] VSS unitsource2u
xsrc[29] VDD Vpbias[1] ON[29] ONB[29] Iout Vpcbias[1] VSS unitsource2u
xsrc[28] VDD Vpbias[1] ON[28] ONB[28] Iout Vpcbias[1] VSS unitsource2u
xsrc[27] VDD Vpbias[1] ON[27] ONB[27] Iout Vpcbias[1] VSS unitsource2u
xsrc[26] VDD Vpbias[1] ON[26] ONB[26] Iout Vpcbias[1] VSS unitsource2u
xsrc[25] VDD Vpbias[1] ON[25] ONB[25] Iout Vpcbias[1] VSS unitsource2u
xsrc[24] VDD Vpbias[1] ON[24] ONB[24] Iout Vpcbias[1] VSS unitsource2u
xsrc[23] VDD Vpbias[1] ON[23] ONB[23] Iout Vpcbias[1] VSS unitsource2u
xsrc[22] VDD Vpbias[1] ON[22] ONB[22] Iout Vpcbias[1] VSS unitsource2u
xsrc[21] VDD Vpbias[1] ON[21] ONB[21] Iout Vpcbias[1] VSS unitsource2u
xsrc[20] VDD Vpbias[1] ON[20] ONB[20] Iout Vpcbias[1] VSS unitsource2u
xsrc[19] VDD Vpbias[1] ON[19] ONB[19] Iout Vpcbias[1] VSS unitsource2u
xsrc[18] VDD Vpbias[1] ON[18] ONB[18] Iout Vpcbias[1] VSS unitsource2u
xsrc[17] VDD Vpbias[1] ON[17] ONB[17] Iout Vpcbias[1] VSS unitsource2u
xsrc[16] VDD Vpbias[1] ON[16] ONB[16] Iout Vpcbias[1] VSS unitsource2u
.ends

* expanding   symbol:  dacbuffer.sym # of pins=9
** sym_path: /home/cmaier/EDA/PUDDING/xschem/dacbuffer.sym
** sch_path: /home/cmaier/EDA/PUDDING/xschem/dacbuffer.sch
.subckt dacbuffer VDD C00 C20 C21 C01 C10 C30 C31 C11
*.PININFO VDD:B C00:B C01:B C10:B C11:B C20:B C21:B C30:B C31:B
x0 VDD C00 C01 C11 C10 dacbuffer_2chan
x1 VDD C20 C21 C31 C30 dacbuffer_2chan
.ends

* expanding   symbol:  dacendbuffer.sym # of pins=5
** sym_path: /home/cmaier/EDA/PUDDING/xschem/dacendbuffer.sym
** sch_path: /home/cmaier/EDA/PUDDING/xschem/dacendbuffer.sch
.subckt dacendbuffer VDD C00 C01 C11 C10
*.PININFO VDD:B C00:B C01:B C10:B C11:B
x0 VDD C00 C01 dacbuffer_1chan
x1 VDD C10 C11 dacbuffer_1chan
.ends

* expanding   symbol:  unitsource2u.sym # of pins=7
** sym_path: /home/cmaier/EDA/PUDDING/xschem/unitsource2u.sym
** sch_path: /home/cmaier/EDA/PUDDING/xschem/unitsource2u.sch
.subckt unitsource2u VDD VbiasP ON ONB Iout VcascP VSS
*.PININFO VSS:B VDD:B VbiasP:B VcascP:B ON:I ONB:I Iout:B
xnonoverlap VDD VSS ON ONB on_n off_n nonoverlap
xsw VDD off_n Vcasc on_n VcascP cascodeswitch_pmos
xsrc VDD VbiasP Vcasc Iout pcsource2u
.ends

* expanding   symbol:  dacbuffer_2chan.sym # of pins=5
** sym_path: /home/cmaier/EDA/PUDDING/xschem/dacbuffer_2chan.sym
** sch_path: /home/cmaier/EDA/PUDDING/xschem/dacbuffer_2chan.sch
.subckt dacbuffer_2chan VDD C00 C01 C11 C10
*.PININFO VDD:B C00:B C01:B C10:B C11:B
x0 VDD C00 C01 dacbuffer_1chan
x1 VDD C10 C11 dacbuffer_1chan
.ends

* expanding   symbol:  dacbuffer_1chan.sym # of pins=3
** sym_path: /home/cmaier/EDA/PUDDING/xschem/dacbuffer_1chan.sym
** sch_path: /home/cmaier/EDA/PUDDING/xschem/dacbuffer_1chan.sch
.subckt dacbuffer_1chan VDD C0 C1
*.PININFO VDD:B C0:B C1:B
M1 VDD C1 VDD VDD sg13_hv_pmos w=14.6u l=4.04u ng=1 m=1
M0 VDD C0 VDD VDD sg13_hv_pmos w=14.6u l=4.04u ng=1 m=1
.ends

* expanding   symbol:  nonoverlap.sym # of pins=6
** sym_path: /home/cmaier/EDA/PUDDING/xschem/nonoverlap.sym
** sch_path: /home/cmaier/EDA/PUDDING/xschem/nonoverlap.sch
.subckt nonoverlap VDD VSS INP INN OUTN OUTP
*.PININFO VSS:B VDD:B INP:I INN:I OUTP:O OUTN:O
M1 OUTN INP VDD VDD sg13_lv_pmos w=0.3u l=0.13u ng=1 m=1
M2 OUTP INN VDD VDD sg13_lv_pmos w=0.3u l=0.13u ng=1 m=1
M3 OUTN OUTP VSS VSS sg13_lv_nmos w=0.15u l=0.52u ng=1 m=1
M4 OUTP OUTN VSS VSS sg13_lv_nmos w=0.15u l=0.52u ng=1 m=1
.ends

* expanding   symbol:  cascodeswitch_pmos.sym # of pins=5
** sym_path: /home/cmaier/EDA/PUDDING/xschem/cascodeswitch_pmos.sym
** sch_path: /home/cmaier/EDA/PUDDING/xschem/cascodeswitch_pmos.sch
.subckt cascodeswitch_pmos VDD off_n Vcasc on_n Vbpcasc
*.PININFO off_n:I Vbpcasc:I Vcasc:O on_n:I VDD:I
Mpullup Vcasc off_n VDD VDD sg13_lv_pmos w=0.3u l=0.13u ng=1 m=1
Mbias Vbpcasc on_n Vcasc VDD sg13_lv_pmos w=0.3u l=0.13u ng=1 m=1
.ends

* expanding   symbol:  pcsource2u.sym # of pins=4
** sym_path: /home/cmaier/EDA/PUDDING/xschem/pcsource2u.sym
** sch_path: /home/cmaier/EDA/PUDDING/xschem/pcsource2u.sch
.subckt pcsource2u VDD VbiasP VcascodeP Iout
*.PININFO VcascodeP:I VbiasP:I Iout:O VDD:I
Msrc drain VbiasP VDD VDD sg13_lv_pmos w=1.45u l=5u ng=1 m=1
Mcasc Iout VcascodeP drain VDD sg13_lv_pmos w=1.2u l=0.6u ng=1 m=1
.ends

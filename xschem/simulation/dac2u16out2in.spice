** sch_path: /home/cmaier/EDA/PUDDING/xschem/dac2u16out2in.sch
.subckt dac2u16out2in Iout ON[15] ON[14] ON[13] ON[12] ON[11] ON[10] ON[9] ON[8] ON[7] ON[6] ON[5] ON[4] ON[3] ON[2] ON[1] ON[0]
+ ONB[15] ONB[14] ONB[13] ONB[12] ONB[11] ONB[10] ONB[9] ONB[8] ONB[7] ONB[6] ONB[5] ONB[4] ONB[3] ONB[2] ONB[1] ONB[0] VSS VDD Vpcbias
+ EN[1] EN[0] ENB[1] ENB[0]
*.PININFO Iout:O ON[15:0]:I ONB[15:0]:I VSS:B VDD:B Vpcbias:B EN[1:0]:I ENB[1:0]:I
Mcbias Vpcbias Vpcbias Vpbias VDD sg13_lv_pmos w=5.85u l=0.15u ng=1 m=2
xref[1] VDD Vpbias EN[1] ENB[1] Vpbias Vpcbias VSS unitsource2u
xref[0] VDD Vpbias EN[0] ENB[0] Vpbias Vpcbias VSS unitsource2u
xsrc[15] VDD Vpbias ON[15] ONB[15] Iout Vpcbias VSS unitsource2u
xsrc[14] VDD Vpbias ON[14] ONB[14] Iout Vpcbias VSS unitsource2u
xsrc[13] VDD Vpbias ON[13] ONB[13] Iout Vpcbias VSS unitsource2u
xsrc[12] VDD Vpbias ON[12] ONB[12] Iout Vpcbias VSS unitsource2u
xsrc[11] VDD Vpbias ON[11] ONB[11] Iout Vpcbias VSS unitsource2u
xsrc[10] VDD Vpbias ON[10] ONB[10] Iout Vpcbias VSS unitsource2u
xsrc[9] VDD Vpbias ON[9] ONB[9] Iout Vpcbias VSS unitsource2u
xsrc[8] VDD Vpbias ON[8] ONB[8] Iout Vpcbias VSS unitsource2u
xsrc[7] VDD Vpbias ON[7] ONB[7] Iout Vpcbias VSS unitsource2u
xsrc[6] VDD Vpbias ON[6] ONB[6] Iout Vpcbias VSS unitsource2u
xsrc[5] VDD Vpbias ON[5] ONB[5] Iout Vpcbias VSS unitsource2u
xsrc[4] VDD Vpbias ON[4] ONB[4] Iout Vpcbias VSS unitsource2u
xsrc[3] VDD Vpbias ON[3] ONB[3] Iout Vpcbias VSS unitsource2u
xsrc[2] VDD Vpbias ON[2] ONB[2] Iout Vpcbias VSS unitsource2u
xsrc[1] VDD Vpbias ON[1] ONB[1] Iout Vpcbias VSS unitsource2u
xsrc[0] VDD Vpbias ON[0] ONB[0] Iout Vpcbias VSS unitsource2u
**** begin user architecture code

* device parameters
.param l      = 5u
.param w      = 1.45u
.param lc     = 0.6u
.param wc     = 1.2u
.param lb     = 0.15u
.param wb     = 5.85u
.param lplogic= 0.13u
.param wplogic= 0.5u
.param lnlogic= 0.13u
.param wnlogic= 0.15u

**** end user architecture code
.ends

* expanding   symbol:  unitsource2u.sym # of pins=7
** sym_path: /home/cmaier/EDA/PUDDING/xschem/unitsource2u.sym
** sch_path: /home/cmaier/EDA/PUDDING/xschem/unitsource2u.sch
.subckt unitsource2u VDD VbiasP ON ONB Iout VcascP VSS
*.PININFO VSS:B VDD:B VbiasP:B VcascP:B ON:I ONB:I Iout:B
xnonoverlap VDD VSS ON ONB on_n off_n nonoverlap
xsw VDD off_n Vcasc on_n VcascP cascodeswitch_pmos
xsrc VDD VbiasP Vcasc Iout pcsource2u
.ends

* expanding   symbol:  nonoverlap.sym # of pins=6
** sym_path: /home/cmaier/EDA/PUDDING/xschem/nonoverlap.sym
** sch_path: /home/cmaier/EDA/PUDDING/xschem/nonoverlap.sch
.subckt nonoverlap VDD VSS INP INN OUTN OUTP
*.PININFO VSS:B VDD:B INP:I INN:I OUTP:O OUTN:O
M1 OUTN INP VDD VDD sg13_lv_pmos w=0.3u l=0.13u ng=1 m=1
M2 OUTP INN VDD VDD sg13_lv_pmos w=0.3u l=0.13u ng=1 m=1
M3 OUTN OUTP VSS VSS sg13_lv_nmos w=0.15u l=0.52u ng=1 m=1
M4 OUTP OUTN VSS VSS sg13_lv_nmos w=0.15u l=0.52u ng=1 m=1
.ends

* expanding   symbol:  cascodeswitch_pmos.sym # of pins=5
** sym_path: /home/cmaier/EDA/PUDDING/xschem/cascodeswitch_pmos.sym
** sch_path: /home/cmaier/EDA/PUDDING/xschem/cascodeswitch_pmos.sch
.subckt cascodeswitch_pmos VDD off_n Vcasc on_n Vbpcasc
*.PININFO off_n:I Vbpcasc:I Vcasc:O on_n:I VDD:I
Mpullup Vcasc off_n VDD VDD sg13_lv_pmos w=0.3u l=0.13u ng=1 m=1
Mbias Vbpcasc on_n Vcasc VDD sg13_lv_pmos w=0.3u l=0.13u ng=1 m=1
.ends

* expanding   symbol:  pcsource2u.sym # of pins=4
** sym_path: /home/cmaier/EDA/PUDDING/xschem/pcsource2u.sym
** sch_path: /home/cmaier/EDA/PUDDING/xschem/pcsource2u.sch
.subckt pcsource2u VDD VbiasP VcascodeP Iout
*.PININFO VcascodeP:I VbiasP:I Iout:O VDD:I
Msrc drain VbiasP VDD VDD sg13_lv_pmos w=1.45u l=5u ng=1 m=1
Mcasc Iout VcascodeP drain VDD sg13_lv_pmos w=1.2u l=0.6u ng=1 m=1
.ends

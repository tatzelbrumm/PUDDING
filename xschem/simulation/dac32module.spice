** sch_path: /home/cmaier/EDA/PUDDING/xschem/dac32module.sch
.subckt dac32module VDD EN[3] EN[2] EN[1] EN[0] ENB[3] ENB[2] ENB[1] ENB[0] ON[31] ON[30] ON[29] ON[28] ON[27] ON[26] ON[25]
+ ON[24] ON[23] ON[22] ON[21] ON[20] ON[19] ON[18] ON[17] ON[16] ON[15] ON[14] ON[13] ON[12] ON[11] ON[10] ON[9] ON[8] ON[7] ON[6] ON[5]
+ ON[4] ON[3] ON[2] ON[1] ON[0] ONB[31] ONB[30] ONB[29] ONB[28] ONB[27] ONB[26] ONB[25] ONB[24] ONB[23] ONB[22] ONB[21] ONB[20] ONB[19]
+ ONB[18] ONB[17] ONB[16] ONB[15] ONB[14] ONB[13] ONB[12] ONB[11] ONB[10] ONB[9] ONB[8] ONB[7] ONB[6] ONB[5] ONB[4] ONB[3] ONB[2] ONB[1]
+ ONB[0] Iout Vpbias[1] Vpbias[0] Vpcbias[1] Vpcbias[0] VSS
*.PININFO Iout:O ON[31:0]:I ONB[31:0]:I VSS:B VDD:B Vpcbias[1:0]:B EN[3:0]:I ENB[3:0]:I Vpbias[1:0]:B
Mcbias[0] Vpcbias[0] Vpcbias[0] Vpbias[0] VDD sg13_lv_pmos w=5.85u l=0.15u ng=1 m=2
xref[1] VDD Vpbias[0] EN[1] ENB[1] Vpbias[0] Vpcbias[0] VSS unitsource2u
xref[0] VDD Vpbias[0] EN[0] ENB[0] Vpbias[0] Vpcbias[0] VSS unitsource2u
xsrc[15] VDD Vpbias[0] ON[15] ONB[15] Iout Vpcbias[0] VSS unitsource2u
xsrc[14] VDD Vpbias[0] ON[14] ONB[14] Iout Vpcbias[0] VSS unitsource2u
xsrc[13] VDD Vpbias[0] ON[13] ONB[13] Iout Vpcbias[0] VSS unitsource2u
xsrc[12] VDD Vpbias[0] ON[12] ONB[12] Iout Vpcbias[0] VSS unitsource2u
xsrc[11] VDD Vpbias[0] ON[11] ONB[11] Iout Vpcbias[0] VSS unitsource2u
xsrc[10] VDD Vpbias[0] ON[10] ONB[10] Iout Vpcbias[0] VSS unitsource2u
xsrc[9] VDD Vpbias[0] ON[9] ONB[9] Iout Vpcbias[0] VSS unitsource2u
xsrc[8] VDD Vpbias[0] ON[8] ONB[8] Iout Vpcbias[0] VSS unitsource2u
xsrc[7] VDD Vpbias[0] ON[7] ONB[7] Iout Vpcbias[0] VSS unitsource2u
xsrc[6] VDD Vpbias[0] ON[6] ONB[6] Iout Vpcbias[0] VSS unitsource2u
xsrc[5] VDD Vpbias[0] ON[5] ONB[5] Iout Vpcbias[0] VSS unitsource2u
xsrc[4] VDD Vpbias[0] ON[4] ONB[4] Iout Vpcbias[0] VSS unitsource2u
xsrc[3] VDD Vpbias[0] ON[3] ONB[3] Iout Vpcbias[0] VSS unitsource2u
xsrc[2] VDD Vpbias[0] ON[2] ONB[2] Iout Vpcbias[0] VSS unitsource2u
xsrc[1] VDD Vpbias[0] ON[1] ONB[1] Iout Vpcbias[0] VSS unitsource2u
xsrc[0] VDD Vpbias[0] ON[0] ONB[0] Iout Vpcbias[0] VSS unitsource2u
Mcbias[1] Vpcbias[1] Vpcbias[1] Vpbias[1] VDD sg13_lv_pmos w=5.85u l=0.15u ng=1 m=2
xref1[3] VDD Vpbias[1] EN[3] ENB[3] Vpbias[1] Vpcbias[1] VSS unitsource2u
xref1[2] VDD Vpbias[1] EN[2] ENB[2] Vpbias[1] Vpcbias[1] VSS unitsource2u
xsrc1[31] VDD Vpbias[1] ON[31] ONB[31] Iout Vpcbias[1] VSS unitsource2u
xsrc1[30] VDD Vpbias[1] ON[30] ONB[30] Iout Vpcbias[1] VSS unitsource2u
xsrc1[29] VDD Vpbias[1] ON[29] ONB[29] Iout Vpcbias[1] VSS unitsource2u
xsrc1[28] VDD Vpbias[1] ON[28] ONB[28] Iout Vpcbias[1] VSS unitsource2u
xsrc1[27] VDD Vpbias[1] ON[27] ONB[27] Iout Vpcbias[1] VSS unitsource2u
xsrc1[26] VDD Vpbias[1] ON[26] ONB[26] Iout Vpcbias[1] VSS unitsource2u
xsrc1[25] VDD Vpbias[1] ON[25] ONB[25] Iout Vpcbias[1] VSS unitsource2u
xsrc1[24] VDD Vpbias[1] ON[24] ONB[24] Iout Vpcbias[1] VSS unitsource2u
xsrc1[23] VDD Vpbias[1] ON[23] ONB[23] Iout Vpcbias[1] VSS unitsource2u
xsrc1[22] VDD Vpbias[1] ON[22] ONB[22] Iout Vpcbias[1] VSS unitsource2u
xsrc1[21] VDD Vpbias[1] ON[21] ONB[21] Iout Vpcbias[1] VSS unitsource2u
xsrc1[20] VDD Vpbias[1] ON[20] ONB[20] Iout Vpcbias[1] VSS unitsource2u
xsrc1[19] VDD Vpbias[1] ON[19] ONB[19] Iout Vpcbias[1] VSS unitsource2u
xsrc1[18] VDD Vpbias[1] ON[18] ONB[18] Iout Vpcbias[1] VSS unitsource2u
xsrc1[17] VDD Vpbias[1] ON[17] ONB[17] Iout Vpcbias[1] VSS unitsource2u
xsrc1[16] VDD Vpbias[1] ON[16] ONB[16] Iout Vpcbias[1] VSS unitsource2u
* tap: EN[3:0] --> EN[1:0]
* tap: ENB[3:0] --> ENB[1:0]
* tap: ENB[3:0] --> ENB[3:2]
* tap: EN[3:0] --> EN[3:2]
* tap: ON[31:0] --> ON[15:0]
* tap: ONB[31:0] --> ONB[15:0]
* tap: ON[31:0] --> ON[31:16]
* tap: ONB[31:0] --> ONB[31:16]
* tap: Vpbias[1:0] --> Vpbias[0]
* tap: Vpcbias[1:0] --> Vpcbias[0]
* tap: Vpbias[1:0] --> Vpbias[1]
* tap: Vpcbias[1:0] --> Vpcbias[1]
**** begin user architecture code

* device parameters
.param l      = 5u
.param w      = 1.45u
.param lc     = 0.6u
.param wc     = 1.2u
.param lb     = 0.15u
.param wb     = 5.85u
.param lplogic= 0.13u
.param wplogic= 0.5u
.param lnlogic= 0.13u
.param wnlogic= 0.15u

**** end user architecture code
.ends

* expanding   symbol:  unitsource2u.sym # of pins=7
** sym_path: /home/cmaier/EDA/PUDDING/xschem/unitsource2u.sym
** sch_path: /home/cmaier/EDA/PUDDING/xschem/unitsource2u.sch
.subckt unitsource2u VDD VbiasP ON ONB Iout VcascP VSS
*.PININFO VSS:B VDD:B VbiasP:B VcascP:B ON:I ONB:I Iout:B
xnonoverlap VDD VSS ON ONB on_n off_n nonoverlap
xsw VDD off_n Vcasc on_n VcascP cascodeswitch_pmos
xsrc VDD VbiasP Vcasc Iout pcsource2u
.ends

* expanding   symbol:  nonoverlap.sym # of pins=6
** sym_path: /home/cmaier/EDA/PUDDING/xschem/nonoverlap.sym
** sch_path: /home/cmaier/EDA/PUDDING/xschem/nonoverlap.sch
.subckt nonoverlap VDD VSS INP INN OUTN OUTP
*.PININFO VSS:B VDD:B INP:I INN:I OUTP:O OUTN:O
M1 OUTN INP VDD VDD sg13_lv_pmos w=0.3u l=0.13u ng=1 m=1
M2 OUTP INN VDD VDD sg13_lv_pmos w=0.3u l=0.13u ng=1 m=1
M3 OUTN OUTP VSS VSS sg13_lv_nmos w=0.15u l=0.52u ng=1 m=1
M4 OUTP OUTN VSS VSS sg13_lv_nmos w=0.15u l=0.52u ng=1 m=1
.ends

* expanding   symbol:  cascodeswitch_pmos.sym # of pins=5
** sym_path: /home/cmaier/EDA/PUDDING/xschem/cascodeswitch_pmos.sym
** sch_path: /home/cmaier/EDA/PUDDING/xschem/cascodeswitch_pmos.sch
.subckt cascodeswitch_pmos VDD off_n Vcasc on_n Vbpcasc
*.PININFO off_n:I Vbpcasc:I Vcasc:O on_n:I VDD:I
Mpullup Vcasc off_n VDD VDD sg13_lv_pmos w=0.3u l=0.13u ng=1 m=1
Mbias Vbpcasc on_n Vcasc VDD sg13_lv_pmos w=0.3u l=0.13u ng=1 m=1
.ends

* expanding   symbol:  pcsource2u.sym # of pins=4
** sym_path: /home/cmaier/EDA/PUDDING/xschem/pcsource2u.sym
** sch_path: /home/cmaier/EDA/PUDDING/xschem/pcsource2u.sch
.subckt pcsource2u VDD VbiasP VcascodeP Iout
*.PININFO VcascodeP:I VbiasP:I Iout:O VDD:I
Msrc drain VbiasP VDD VDD sg13_lv_pmos w=1.45u l=5u ng=1 m=1
Mcasc Iout VcascodeP drain VDD sg13_lv_pmos w=1.2u l=0.6u ng=1 m=1
.ends

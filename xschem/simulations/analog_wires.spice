** sch_path: /home/cmaier/EDA/PUDDING/xschem/analog_wires.sch
**.subckt analog_wires VbiasP[0] VDDA[1] VcascP[0] Iout i_out i_in VDDA[0] VbiasP[1] VcascP[1]
*.iopin VbiasP[0]
*.iopin VDDA[1]
*.iopin VcascP[0]
*.iopin Iout
*.iopin i_out
*.iopin i_in
*.iopin VDDA[0]
*.iopin VbiasP[1]
*.iopin VcascP[1]
XMcbuffer vdda i_in vdda vdda sg13_hv_pmos w=8u l=8u ng=1 m=19
XMbbuffer vdda bias vdda vdda sg13_hv_pmos w=8u l=8u ng=1 m=19
R1 vdda VDDA[1] 0 m=1
R2 vdda VDDA[0] 0 m=1
R3 bias VbiasP[1] 0 m=1
R4 bias VbiasP[0] 0 m=1
R5 i_in VcascP[1] 0 m=1
R6 i_in VcascP[0] 0 m=1
R7 i_out Iout 0 m=1
**.ends
.end
